procedure(rhWireLabel(cv points name)
  let((w)
    w=schCreateWire(cv "draw" "full" points 0.0625 0.0625 0)
    schCreateWireLabel(cv car(w) car(last(points)) name "lowerLeft" "R0" "stick" 0.09 nil)
  )
)
procedure(rhDevice(cv kind name origin orient width length nets)
  let((master inst point offset finish net term value)
    master=dbOpenCellViewByType("tsmc18rf" if(equal(kind "n") then "nmos2v" else "pmos2v") "symbol" nil "r")
    inst=dbCreateInst(cv master name origin orient)
    dbReplaceProp(inst "w" "string" sprintf(nil "%gu" width))
    dbReplaceProp(inst "l" "string" sprintf(nil "%gu" length))
    dbReplaceProp(inst "m" "string" "1")
    foreach(prop list("ad" "as") dbReplaceProp(inst prop "string" sprintf(nil "%g" width*0.2e-12)))
    foreach(prop list("pd" "ps") dbReplaceProp(inst prop "string" sprintf(nil "%gu" 2*(width+0.2))))
    foreach(term master~>terminals
      net=cadr(assoc(term~>name nets))
      unless(net error("No net supplied for %s.%s" name term~>name))
      point=centerBox(car(term~>pins)~>fig~>bBox)
      offset=cond(
        (equal(term~>name "G") list(-0.625 0.0))
        (equal(term~>name "B") list(0.625 0.0))
        (yCoord(point)>0 list(0.0 0.50))
        (t list(0.0 -0.50))
      )
      finish=list(xCoord(point)+xCoord(offset) yCoord(point)+yCoord(offset))
      point=dbTransformPoint(point inst~>transform)
      finish=dbTransformPoint(finish inst~>transform)
      rhWireLabel(cv list(point finish) net)
    )
    inst
  )
)
procedure(rhPort(cv name direction xy)
  let((master endpoint)
    master=dbOpenCellViewByType("basic" if(equal(direction "input") then "ipin" else "iopin") "symbol" nil "r")
    schCreatePin(cv master name direction nil xy "R0")
    endpoint=list(xCoord(xy)+0.75 yCoord(xy))
    rhWireLabel(cv list(xy endpoint) name)
  )
)

simulator('spectre)
procedure(rhAnalog(cv cell name xy nets props)
  let((master inst point finish dx dy)
    master=dbOpenCellViewByType("analogLib" cell "symbol" nil "r")
    inst=dbCreateInst(cv master name xy "R0")
    foreach(prop props dbReplaceProp(inst car(prop) "string" cadr(prop)))
    foreach(term master~>terminals
      point=centerBox(car(term~>pins)~>fig~>bBox)
      if(equal(cell "switch") then
        dx=if(xCoord(point)>0.1 then 0.625 else -0.625)
        dy=0
      else
        dx=0
        dy=if(yCoord(point)>-0.1 then 0.625 else -0.625)
      )
      finish=list(xCoord(point)+dx yCoord(point)+dy)
      rhWireLabel(cv list(dbTransformPoint(point inst~>transform) dbTransformPoint(finish inst~>transform)) cadr(assoc(term~>name nets)))
    )
    inst
  )
)
procedure(rhBlock(cv cell)
  let((master inst point finish)
    master=dbOpenCellViewByType("rh_sram_lib" cell "symbol" nil "r")
    inst=dbCreateInst(cv master "Xcell" list(0 0) "R0")
    foreach(term master~>terminals
      point=centerBox(car(term~>pins)~>fig~>bBox)
      finish=cond(
        (equal(term~>name "VDD") list(xCoord(point) yCoord(point)+0.75))
        (equal(term~>name "VSS") list(xCoord(point) yCoord(point)-0.75))
        (t list(xCoord(point)-0.75 yCoord(point)))
      )
      rhWireLabel(cv list(point finish) term~>name)
    )
  )
)
rhTBReport=outfile("/home/rocky/work/rh_sram/docs/testbench_checks.txt")

cv=dbOpenCellViewByType("rh_sram_lib" "tb_sram6t_functional" "schematic" "schematic" "w")
foreach(inst cv~>instances dbDeleteObject(inst))
foreach(shape cv~>shapes dbDeleteObject(shape))
foreach(term cv~>terminals dbDeleteObject(term))
foreach(net cv~>nets dbDeleteObject(net))
rhBlock(cv "sram6t")
gndMaster=dbOpenCellViewByType("analogLib" "gnd" "symbol" nil "r")
dbCreateInst(cv gndMaster "GND" list(-12 -7) "R0")
rhWireLabel(cv list(list(-12 -7) list(-12 -6.5)) "gnd!")
rhAnalog(cv "vdc" "VSUPPLY" list(-12 7) list(list("PLUS" "VDD") list("MINUS" "gnd!")) list(list("vdc" "1.8")))
rhAnalog(cv "vdc" "VSS_REF" list(-12 4.5) list(list("PLUS" "VSS") list("MINUS" "gnd!")) list(list("vdc" "0")))
rhAnalog(cv "vpwlf" "VWL" list(-12 1.5) list(list("PLUS" "WL") list("MINUS" "gnd!")) list(list("fileName" "/home/rocky/work/rh_sram/stimuli/functional_WL.pwl")))
rhAnalog(cv "vpwlf" "VWE" list(-12 -1.5) list(list("PLUS" "WE") list("MINUS" "gnd!")) list(list("fileName" "/home/rocky/work/rh_sram/stimuli/functional_WE.pwl")))
rhAnalog(cv "vpwlf" "VPC" list(-12 -4.5) list(list("PLUS" "PC") list("MINUS" "gnd!")) list(list("fileName" "/home/rocky/work/rh_sram/stimuli/functional_PC.pwl")))
rhAnalog(cv "vpwlf" "VDATA" list(11 1.5) list(list("PLUS" "DATA") list("MINUS" "gnd!")) list(list("fileName" "/home/rocky/work/rh_sram/stimuli/functional_DATA.pwl")))
rhAnalog(cv "vpwlf" "VDATAB" list(11 -1.5) list(list("PLUS" "DATAB") list("MINUS" "gnd!")) list(list("fileName" "/home/rocky/work/rh_sram/stimuli/functional_DATAB.pwl")))
rhAnalog(cv "switch" "WBL" list(-7 8) list(list("N+" "BL") list("N-" "DATA") list("NC+" "WE") list("NC-" "gnd!")) list(list("vt1" ".8") list("vt2" "1") list("ro" "1T") list("rc" "1")))
rhAnalog(cv "switch" "WBLB" list(6 8) list(list("N+" "BLB") list("N-" "DATAB") list("NC+" "WE") list("NC-" "gnd!")) list(list("vt1" ".8") list("vt2" "1") list("ro" "1T") list("rc" "1")))
inst=rhDevice(cv "p" "PRE1" list(-5 -3.5) "R0" 2.0 0.18 list(list("D" "BL") list("G" "PC") list("S" "VDD") list("B" "VDD")))
dbReplaceProp(inst "ad" "string" "0")
dbReplaceProp(inst "as" "string" "0")
dbReplaceProp(inst "pd" "string" "0")
dbReplaceProp(inst "ps" "string" "0")
dbReplaceProp(inst "nrd" "string" "1")
dbReplaceProp(inst "nrs" "string" "1")
inst=rhDevice(cv "p" "PRE2" list(5 -3.5) "R0" 2.0 0.18 list(list("D" "BLB") list("G" "PC") list("S" "VDD") list("B" "VDD")))
dbReplaceProp(inst "ad" "string" "0")
dbReplaceProp(inst "as" "string" "0")
dbReplaceProp(inst "pd" "string" "0")
dbReplaceProp(inst "ps" "string" "0")
dbReplaceProp(inst "nrd" "string" "1")
dbReplaceProp(inst "nrs" "string" "1")
rhAnalog(cv "cap" "CBL" list(-3 -6) list(list("PLUS" "BL") list("MINUS" "gnd!")) list(list("c" "100f")))
rhAnalog(cv "cap" "CBLB" list(3 -6) list(list("PLUS" "BLB") list("MINUS" "gnd!")) list(list("c" "100f")))
dbCreateLabel(cv list("text" "drawing") list(-6 10) "TB_SRAM6T_FUNCTIONAL" "lowerLeft" "R0" "stick" .3)
schCheck(cv)
dbSave(cv)
fprintf(rhTBReport "tb_sram6t_functional markers=%d\n" length(cv~>markers))
dbClose(cv)
envSetVal("asimenv.startup" "projectDir" 'string "/home/rocky/work/rh_sram/runs/cadence_netlists")
simulator('spectre)
design("rh_sram_lib" "tb_sram6t_functional" "schematic" "r")
netlistPath=createNetlist(?recreateAll t)
fprintf(rhTBReport "NETLIST tb_sram6t_functional %L\n" netlistPath)
cv=dbOpenCellViewByType("rh_sram_lib" "tb_sram6t_seu" "schematic" "schematic" "w")
foreach(inst cv~>instances dbDeleteObject(inst))
foreach(shape cv~>shapes dbDeleteObject(shape))
foreach(term cv~>terminals dbDeleteObject(term))
foreach(net cv~>nets dbDeleteObject(net))
rhDevice(cv "p" "P1" list(-2.5 4) "R0" 0.3 0.18 list(list("D" "Q") list("G" "QN") list("S" "VDD") list("B" "VDD")))
rhDevice(cv "p" "P2" list(2.5 4) "R0" 0.3 0.18 list(list("D" "QN") list("G" "Q") list("S" "VDD") list("B" "VDD")))
rhDevice(cv "n" "N1" list(-2.5 1) "R0" 0.8 0.18 list(list("D" "Q") list("G" "QN") list("S" "VSS") list("B" "VSS")))
rhDevice(cv "n" "N2" list(2.5 1) "R0" 0.8 0.18 list(list("D" "QN") list("G" "Q") list("S" "VSS") list("B" "VSS")))
rhDevice(cv "n" "N3" list(-6 2.5) "R90" 0.4 0.18 list(list("D" "Q") list("G" "WL") list("S" "BL") list("B" "VSS")))
rhDevice(cv "n" "N4" list(6 2.5) "R90" 0.4 0.18 list(list("D" "QN") list("G" "WL") list("S" "BLB") list("B" "VSS")))
gndMaster=dbOpenCellViewByType("analogLib" "gnd" "symbol" nil "r")
dbCreateInst(cv gndMaster "GND" list(-12 -7) "R0")
rhWireLabel(cv list(list(-12 -7) list(-12 -6.5)) "gnd!")
rhAnalog(cv "vdc" "VSUPPLY" list(-12 7) list(list("PLUS" "VDD") list("MINUS" "gnd!")) list(list("vdc" "1.8")))
rhAnalog(cv "vdc" "VSS_REF" list(-12 4.5) list(list("PLUS" "VSS") list("MINUS" "gnd!")) list(list("vdc" "0")))
rhAnalog(cv "vpwlf" "VWL" list(-12 1.5) list(list("PLUS" "WL") list("MINUS" "gnd!")) list(list("fileName" "/home/rocky/work/rh_sram/stimuli/seu_WL.pwl")))
rhAnalog(cv "vpwlf" "VWE" list(-12 -1.5) list(list("PLUS" "WE") list("MINUS" "gnd!")) list(list("fileName" "/home/rocky/work/rh_sram/stimuli/seu_WE.pwl")))
rhAnalog(cv "vpwlf" "VPC" list(-12 -4.5) list(list("PLUS" "PC") list("MINUS" "gnd!")) list(list("fileName" "/home/rocky/work/rh_sram/stimuli/seu_PC.pwl")))
rhAnalog(cv "vpwlf" "VDATA" list(11 1.5) list(list("PLUS" "DATA") list("MINUS" "gnd!")) list(list("fileName" "/home/rocky/work/rh_sram/stimuli/seu_DATA.pwl")))
rhAnalog(cv "vpwlf" "VDATAB" list(11 -1.5) list(list("PLUS" "DATAB") list("MINUS" "gnd!")) list(list("fileName" "/home/rocky/work/rh_sram/stimuli/seu_DATAB.pwl")))
rhAnalog(cv "switch" "WBL" list(-7 8) list(list("N+" "BL") list("N-" "DATA") list("NC+" "WE") list("NC-" "gnd!")) list(list("vt1" ".8") list("vt2" "1") list("ro" "1T") list("rc" "1")))
rhAnalog(cv "switch" "WBLB" list(6 8) list(list("N+" "BLB") list("N-" "DATAB") list("NC+" "WE") list("NC-" "gnd!")) list(list("vt1" ".8") list("vt2" "1") list("ro" "1T") list("rc" "1")))
inst=rhDevice(cv "p" "PRE1" list(-5 -3.5) "R0" 2.0 0.18 list(list("D" "BL") list("G" "PC") list("S" "VDD") list("B" "VDD")))
dbReplaceProp(inst "ad" "string" "0")
dbReplaceProp(inst "as" "string" "0")
dbReplaceProp(inst "pd" "string" "0")
dbReplaceProp(inst "ps" "string" "0")
dbReplaceProp(inst "nrd" "string" "1")
dbReplaceProp(inst "nrs" "string" "1")
inst=rhDevice(cv "p" "PRE2" list(5 -3.5) "R0" 2.0 0.18 list(list("D" "BLB") list("G" "PC") list("S" "VDD") list("B" "VDD")))
dbReplaceProp(inst "ad" "string" "0")
dbReplaceProp(inst "as" "string" "0")
dbReplaceProp(inst "pd" "string" "0")
dbReplaceProp(inst "ps" "string" "0")
dbReplaceProp(inst "nrd" "string" "1")
dbReplaceProp(inst "nrs" "string" "1")
rhAnalog(cv "cap" "CBL" list(-3 -6) list(list("PLUS" "BL") list("MINUS" "gnd!")) list(list("c" "100f")))
rhAnalog(cv "cap" "CBLB" list(3 -6) list(list("PLUS" "BLB") list("MINUS" "gnd!")) list(list("c" "100f")))
rhAnalog(cv "vdc" "VSEUMON" list(11 7) list(list("PLUS" "QN") list("MINUS" "INJECT")) list(list("vdc" "0")))
rhAnalog(cv "ipwlf" "ISEU" list(11 4.5) list(list("PLUS" "INJECT") list("MINUS" "gnd!")) list(list("fileName" "/home/rocky/work/rh_sram/stimuli/seu_30fC.pwl")))
dbCreateLabel(cv list("text" "drawing") list(-6 10) "TB_SRAM6T_SEU" "lowerLeft" "R0" "stick" .3)
schCheck(cv)
dbSave(cv)
fprintf(rhTBReport "tb_sram6t_seu markers=%d\n" length(cv~>markers))
dbClose(cv)
envSetVal("asimenv.startup" "projectDir" 'string "/home/rocky/work/rh_sram/runs/cadence_netlists")
simulator('spectre)
design("rh_sram_lib" "tb_sram6t_seu" "schematic" "r")
netlistPath=createNetlist(?recreateAll t)
fprintf(rhTBReport "NETLIST tb_sram6t_seu %L\n" netlistPath)
cv=dbOpenCellViewByType("rh_sram_lib" "tb_hphs12t_functional" "schematic" "schematic" "w")
foreach(inst cv~>instances dbDeleteObject(inst))
foreach(shape cv~>shapes dbDeleteObject(shape))
foreach(term cv~>terminals dbDeleteObject(term))
foreach(net cv~>nets dbDeleteObject(net))
rhBlock(cv "hphs12t")
gndMaster=dbOpenCellViewByType("analogLib" "gnd" "symbol" nil "r")
dbCreateInst(cv gndMaster "GND" list(-12 -7) "R0")
rhWireLabel(cv list(list(-12 -7) list(-12 -6.5)) "gnd!")
rhAnalog(cv "vdc" "VSUPPLY" list(-12 7) list(list("PLUS" "VDD") list("MINUS" "gnd!")) list(list("vdc" "1.8")))
rhAnalog(cv "vdc" "VSS_REF" list(-12 4.5) list(list("PLUS" "VSS") list("MINUS" "gnd!")) list(list("vdc" "0")))
rhAnalog(cv "vpwlf" "VWL" list(-12 1.5) list(list("PLUS" "WL") list("MINUS" "gnd!")) list(list("fileName" "/home/rocky/work/rh_sram/stimuli/functional_WL.pwl")))
rhAnalog(cv "vpwlf" "VWE" list(-12 -1.5) list(list("PLUS" "WE") list("MINUS" "gnd!")) list(list("fileName" "/home/rocky/work/rh_sram/stimuli/functional_WE.pwl")))
rhAnalog(cv "vpwlf" "VPC" list(-12 -4.5) list(list("PLUS" "PC") list("MINUS" "gnd!")) list(list("fileName" "/home/rocky/work/rh_sram/stimuli/functional_PC.pwl")))
rhAnalog(cv "vpwlf" "VDATA" list(11 1.5) list(list("PLUS" "DATA") list("MINUS" "gnd!")) list(list("fileName" "/home/rocky/work/rh_sram/stimuli/functional_DATA.pwl")))
rhAnalog(cv "vpwlf" "VDATAB" list(11 -1.5) list(list("PLUS" "DATAB") list("MINUS" "gnd!")) list(list("fileName" "/home/rocky/work/rh_sram/stimuli/functional_DATAB.pwl")))
rhAnalog(cv "switch" "WBL" list(-7 8) list(list("N+" "BL") list("N-" "DATA") list("NC+" "WE") list("NC-" "gnd!")) list(list("vt1" ".8") list("vt2" "1") list("ro" "1T") list("rc" "1")))
rhAnalog(cv "switch" "WBLB" list(6 8) list(list("N+" "BLB") list("N-" "DATAB") list("NC+" "WE") list("NC-" "gnd!")) list(list("vt1" ".8") list("vt2" "1") list("ro" "1T") list("rc" "1")))
inst=rhDevice(cv "p" "PRE1" list(-5 -3.5) "R0" 2.0 0.18 list(list("D" "BL") list("G" "PC") list("S" "VDD") list("B" "VDD")))
dbReplaceProp(inst "ad" "string" "0")
dbReplaceProp(inst "as" "string" "0")
dbReplaceProp(inst "pd" "string" "0")
dbReplaceProp(inst "ps" "string" "0")
dbReplaceProp(inst "nrd" "string" "1")
dbReplaceProp(inst "nrs" "string" "1")
inst=rhDevice(cv "p" "PRE2" list(5 -3.5) "R0" 2.0 0.18 list(list("D" "BLB") list("G" "PC") list("S" "VDD") list("B" "VDD")))
dbReplaceProp(inst "ad" "string" "0")
dbReplaceProp(inst "as" "string" "0")
dbReplaceProp(inst "pd" "string" "0")
dbReplaceProp(inst "ps" "string" "0")
dbReplaceProp(inst "nrd" "string" "1")
dbReplaceProp(inst "nrs" "string" "1")
rhAnalog(cv "cap" "CBL" list(-3 -6) list(list("PLUS" "BL") list("MINUS" "gnd!")) list(list("c" "100f")))
rhAnalog(cv "cap" "CBLB" list(3 -6) list(list("PLUS" "BLB") list("MINUS" "gnd!")) list(list("c" "100f")))
dbCreateLabel(cv list("text" "drawing") list(-6 10) "TB_HPHS12T_FUNCTIONAL" "lowerLeft" "R0" "stick" .3)
schCheck(cv)
dbSave(cv)
fprintf(rhTBReport "tb_hphs12t_functional markers=%d\n" length(cv~>markers))
dbClose(cv)
envSetVal("asimenv.startup" "projectDir" 'string "/home/rocky/work/rh_sram/runs/cadence_netlists")
simulator('spectre)
design("rh_sram_lib" "tb_hphs12t_functional" "schematic" "r")
netlistPath=createNetlist(?recreateAll t)
fprintf(rhTBReport "NETLIST tb_hphs12t_functional %L\n" netlistPath)
cv=dbOpenCellViewByType("rh_sram_lib" "tb_hphs12t_seu" "schematic" "schematic" "w")
foreach(inst cv~>instances dbDeleteObject(inst))
foreach(shape cv~>shapes dbDeleteObject(shape))
foreach(term cv~>terminals dbDeleteObject(term))
foreach(net cv~>nets dbDeleteObject(net))
rhDevice(cv "p" "P1" list(-2.5 6) "R0" 0.3 0.18 list(list("D" "Q") list("G" "QN") list("S" "VDD") list("B" "VDD")))
rhDevice(cv "p" "P2" list(2.5 6) "R0" 0.3 0.18 list(list("D" "QN") list("G" "Q") list("S" "VDD") list("B" "VDD")))
rhDevice(cv "n" "N1" list(-2.5 0) "R0" 2.4 0.18 list(list("D" "S0") list("G" "S1") list("S" "VSS") list("B" "VSS")))
rhDevice(cv "n" "N2" list(2.5 0) "R0" 2.4 0.18 list(list("D" "S1") list("G" "S0") list("S" "VSS") list("B" "VSS")))
rhDevice(cv "n" "N3" list(-2.5 2.5) "R0" 0.8 0.18 list(list("D" "Q") list("G" "S1") list("S" "S0") list("B" "VSS")))
rhDevice(cv "n" "N4" list(2.5 2.5) "R0" 0.8 0.18 list(list("D" "QN") list("G" "S0") list("S" "S1") list("B" "VSS")))
rhDevice(cv "n" "N5" list(-0.9 4.3) "R0" 0.22 0.18 list(list("D" "VDD") list("G" "Q") list("S" "S0") list("B" "VSS")))
rhDevice(cv "n" "N6" list(0.9 4.3) "R0" 0.22 0.18 list(list("D" "VDD") list("G" "QN") list("S" "S1") list("B" "VSS")))
rhDevice(cv "n" "N7" list(-6 1) "R90" 0.4 0.18 list(list("D" "S0") list("G" "WL") list("S" "BL") list("B" "VSS")))
rhDevice(cv "n" "N8" list(6 1) "R90" 0.4 0.18 list(list("D" "S1") list("G" "WL") list("S" "BLB") list("B" "VSS")))
rhDevice(cv "n" "N9" list(-6 4.5) "R90" 0.4 0.18 list(list("D" "Q") list("G" "WL") list("S" "BL") list("B" "VSS")))
rhDevice(cv "n" "N10" list(6 4.5) "R90" 0.4 0.18 list(list("D" "QN") list("G" "WL") list("S" "BLB") list("B" "VSS")))
gndMaster=dbOpenCellViewByType("analogLib" "gnd" "symbol" nil "r")
dbCreateInst(cv gndMaster "GND" list(-12 -7) "R0")
rhWireLabel(cv list(list(-12 -7) list(-12 -6.5)) "gnd!")
rhAnalog(cv "vdc" "VSUPPLY" list(-12 7) list(list("PLUS" "VDD") list("MINUS" "gnd!")) list(list("vdc" "1.8")))
rhAnalog(cv "vdc" "VSS_REF" list(-12 4.5) list(list("PLUS" "VSS") list("MINUS" "gnd!")) list(list("vdc" "0")))
rhAnalog(cv "vpwlf" "VWL" list(-12 1.5) list(list("PLUS" "WL") list("MINUS" "gnd!")) list(list("fileName" "/home/rocky/work/rh_sram/stimuli/seu_WL.pwl")))
rhAnalog(cv "vpwlf" "VWE" list(-12 -1.5) list(list("PLUS" "WE") list("MINUS" "gnd!")) list(list("fileName" "/home/rocky/work/rh_sram/stimuli/seu_WE.pwl")))
rhAnalog(cv "vpwlf" "VPC" list(-12 -4.5) list(list("PLUS" "PC") list("MINUS" "gnd!")) list(list("fileName" "/home/rocky/work/rh_sram/stimuli/seu_PC.pwl")))
rhAnalog(cv "vpwlf" "VDATA" list(11 1.5) list(list("PLUS" "DATA") list("MINUS" "gnd!")) list(list("fileName" "/home/rocky/work/rh_sram/stimuli/seu_DATA.pwl")))
rhAnalog(cv "vpwlf" "VDATAB" list(11 -1.5) list(list("PLUS" "DATAB") list("MINUS" "gnd!")) list(list("fileName" "/home/rocky/work/rh_sram/stimuli/seu_DATAB.pwl")))
rhAnalog(cv "switch" "WBL" list(-7 8) list(list("N+" "BL") list("N-" "DATA") list("NC+" "WE") list("NC-" "gnd!")) list(list("vt1" ".8") list("vt2" "1") list("ro" "1T") list("rc" "1")))
rhAnalog(cv "switch" "WBLB" list(6 8) list(list("N+" "BLB") list("N-" "DATAB") list("NC+" "WE") list("NC-" "gnd!")) list(list("vt1" ".8") list("vt2" "1") list("ro" "1T") list("rc" "1")))
inst=rhDevice(cv "p" "PRE1" list(-5 -3.5) "R0" 2.0 0.18 list(list("D" "BL") list("G" "PC") list("S" "VDD") list("B" "VDD")))
dbReplaceProp(inst "ad" "string" "0")
dbReplaceProp(inst "as" "string" "0")
dbReplaceProp(inst "pd" "string" "0")
dbReplaceProp(inst "ps" "string" "0")
dbReplaceProp(inst "nrd" "string" "1")
dbReplaceProp(inst "nrs" "string" "1")
inst=rhDevice(cv "p" "PRE2" list(5 -3.5) "R0" 2.0 0.18 list(list("D" "BLB") list("G" "PC") list("S" "VDD") list("B" "VDD")))
dbReplaceProp(inst "ad" "string" "0")
dbReplaceProp(inst "as" "string" "0")
dbReplaceProp(inst "pd" "string" "0")
dbReplaceProp(inst "ps" "string" "0")
dbReplaceProp(inst "nrd" "string" "1")
dbReplaceProp(inst "nrs" "string" "1")
rhAnalog(cv "cap" "CBL" list(-3 -6) list(list("PLUS" "BL") list("MINUS" "gnd!")) list(list("c" "100f")))
rhAnalog(cv "cap" "CBLB" list(3 -6) list(list("PLUS" "BLB") list("MINUS" "gnd!")) list(list("c" "100f")))
rhAnalog(cv "vdc" "VSEUMON" list(11 7) list(list("PLUS" "QN") list("MINUS" "INJECT")) list(list("vdc" "0")))
rhAnalog(cv "ipwlf" "ISEU" list(11 4.5) list(list("PLUS" "INJECT") list("MINUS" "gnd!")) list(list("fileName" "/home/rocky/work/rh_sram/stimuli/seu_30fC.pwl")))
dbCreateLabel(cv list("text" "drawing") list(-6 10) "TB_HPHS12T_SEU" "lowerLeft" "R0" "stick" .3)
schCheck(cv)
dbSave(cv)
fprintf(rhTBReport "tb_hphs12t_seu markers=%d\n" length(cv~>markers))
dbClose(cv)
envSetVal("asimenv.startup" "projectDir" 'string "/home/rocky/work/rh_sram/runs/cadence_netlists")
simulator('spectre)
design("rh_sram_lib" "tb_hphs12t_seu" "schematic" "r")
netlistPath=createNetlist(?recreateAll t)
fprintf(rhTBReport "NETLIST tb_hphs12t_seu %L\n" netlistPath)
close(rhTBReport)
exit()
