procedure(rhWireLabel(cv points name)
  let((w)
    w=schCreateWire(cv "draw" "full" points 0.0625 0.0625 0)
    schCreateWireLabel(cv car(w) car(last(points)) name "lowerLeft" "R0" "stick" 0.09 nil)
  )
)
procedure(rhDevice(cv kind name origin orient width length nets)
  let((master inst point offset finish net term value)
    master=dbOpenCellViewByType("tsmc18rf" if(equal(kind "n") then "nmos2v" else "pmos2v") "symbol" nil "r")
    inst=dbCreateInst(cv master name origin orient)
    dbReplaceProp(inst "w" "string" sprintf(nil "%gu" width))
    dbReplaceProp(inst "l" "string" sprintf(nil "%gu" length))
    dbReplaceProp(inst "m" "string" "1")
    foreach(prop list("ad" "as") dbReplaceProp(inst prop "string" sprintf(nil "%g" width*0.2e-12)))
    foreach(prop list("pd" "ps") dbReplaceProp(inst prop "string" sprintf(nil "%gu" 2*(width+0.2))))
    foreach(term master~>terminals
      net=cadr(assoc(term~>name nets))
      unless(net error("No net supplied for %s.%s" name term~>name))
      point=centerBox(car(term~>pins)~>fig~>bBox)
      offset=cond(
        (equal(term~>name "G") list(-0.625 0.0))
        (equal(term~>name "B") list(0.625 0.0))
        (yCoord(point)>0 list(0.0 0.50))
        (t list(0.0 -0.50))
      )
      finish=list(xCoord(point)+xCoord(offset) yCoord(point)+yCoord(offset))
      point=dbTransformPoint(point inst~>transform)
      finish=dbTransformPoint(finish inst~>transform)
      rhWireLabel(cv list(point finish) net)
    )
    inst
  )
)
procedure(rhPort(cv name direction xy)
  let((master endpoint)
    master=dbOpenCellViewByType("basic" if(equal(direction "input") then "ipin" else "iopin") "symbol" nil "r")
    schCreatePin(cv master name direction nil xy "R0")
    endpoint=list(xCoord(xy)+0.75 yCoord(xy))
    rhWireLabel(cv list(xy endpoint) name)
  )
)

simulator('spectre)
fp=outfile("/home/rocky/work/rh_sram/docs/presentation_checks.txt")
cv=dbOpenCellViewByType("rh_sram_lib" "sram6t" "schematic" "schematic" "a")
foreach(inst cv~>instances
  when(equal(inst~>libName "tsmc18rf")
    xy=inst~>xy
    dbCreateLabel(cv list("text" "drawing") list(xCoord(xy)-.55 yCoord(xy)+.8) sprintf(nil "%s  W=%s L=%s" inst~>name inst~>w inst~>l) "lowerLeft" "R0" "stick" .12)
  )
)
rhWireLabel(cv list(list(-2.25 2.8125) list(-2.25 1.1875)) "Q")
rhWireLabel(cv list(list(2.75 2.8125) list(2.75 1.1875)) "QN")
rhWireLabel(cv list(list(-2.25 4.1875) list(-2.25 4.75) list(2.75 4.75) list(2.75 4.1875)) "VDD")
rhWireLabel(cv list(list(-2.25 -0.1875) list(-2.25 -0.75) list(2.75 -0.75) list(2.75 -0.1875)) "VSS")
schCheck(cv)
dbSave(cv)
fprintf(fp "sram6t markers=%d\n" length(cv~>markers))
dbClose(cv)
envSetVal("asimenv.startup" "projectDir" 'string "/home/rocky/work/rh_sram/runs/cadence_netlists")
design("rh_sram_lib" "sram6t" "schematic" "r")
createNetlist(?recreateAll t)
cv=dbOpenCellViewByType("rh_sram_lib" "tb_sram6t_seu" "schematic" "schematic" "a")
foreach(inst cv~>instances
  when(equal(inst~>libName "tsmc18rf")
    xy=inst~>xy
    dbCreateLabel(cv list("text" "drawing") list(xCoord(xy)-.55 yCoord(xy)+.8) sprintf(nil "%s  W=%s L=%s" inst~>name inst~>w inst~>l) "lowerLeft" "R0" "stick" .12)
  )
)
rhWireLabel(cv list(list(-2.25 3.3125) list(-2.25 1.6875)) "Q")
rhWireLabel(cv list(list(2.75 3.3125) list(2.75 1.6875)) "QN")
rhWireLabel(cv list(list(-2.25 4.6875) list(-2.25 5.25) list(2.75 5.25) list(2.75 4.6875)) "VDD")
rhWireLabel(cv list(list(-2.25 0.3125) list(-2.25 -0.25) list(2.75 -0.25) list(2.75 0.3125)) "VSS")
schCheck(cv)
dbSave(cv)
fprintf(fp "tb_sram6t_seu markers=%d\n" length(cv~>markers))
dbClose(cv)
envSetVal("asimenv.startup" "projectDir" 'string "/home/rocky/work/rh_sram/runs/cadence_netlists")
design("rh_sram_lib" "tb_sram6t_seu" "schematic" "r")
createNetlist(?recreateAll t)
cv=dbOpenCellViewByType("rh_sram_lib" "tb_sram6t_functional" "schematic" "schematic" "a")
foreach(inst cv~>instances
  when(equal(inst~>libName "tsmc18rf")
    xy=inst~>xy
    dbCreateLabel(cv list("text" "drawing") list(xCoord(xy)-.55 yCoord(xy)+.8) sprintf(nil "%s  W=%s L=%s" inst~>name inst~>w inst~>l) "lowerLeft" "R0" "stick" .12)
  )
)
schCheck(cv)
dbSave(cv)
fprintf(fp "tb_sram6t_functional markers=%d\n" length(cv~>markers))
dbClose(cv)
envSetVal("asimenv.startup" "projectDir" 'string "/home/rocky/work/rh_sram/runs/cadence_netlists")
design("rh_sram_lib" "tb_sram6t_functional" "schematic" "r")
createNetlist(?recreateAll t)
cv=dbOpenCellViewByType("rh_sram_lib" "hphs12t" "schematic" "schematic" "a")
foreach(inst cv~>instances
  when(equal(inst~>libName "tsmc18rf")
    xy=inst~>xy
    dbCreateLabel(cv list("text" "drawing") list(xCoord(xy)-.55 yCoord(xy)+.8) sprintf(nil "%s  W=%s L=%s" inst~>name inst~>w inst~>l) "lowerLeft" "R0" "stick" .12)
  )
)
rhWireLabel(cv list(list(-2.25 5.3125) list(-2.25 3.1875)) "Q")
rhWireLabel(cv list(list(2.75 5.3125) list(2.75 3.1875)) "QN")
rhWireLabel(cv list(list(-2.25 1.8125) list(-2.25 0.6875)) "S0")
rhWireLabel(cv list(list(2.75 1.8125) list(2.75 0.6875)) "S1")
rhWireLabel(cv list(list(-0.65 3.6125) list(-0.65 1.25) list(-2.25 1.25)) "S0")
rhWireLabel(cv list(list(1.15 3.6125) list(1.15 1.25) list(2.75 1.25)) "S1")
rhWireLabel(cv list(list(-2.25 6.6875) list(-2.25 7.2) list(2.75 7.2) list(2.75 6.6875)) "VDD")
rhWireLabel(cv list(list(-2.25 -0.6875) list(-2.25 -1.2) list(2.75 -1.2) list(2.75 -0.6875)) "VSS")
schCheck(cv)
dbSave(cv)
fprintf(fp "hphs12t markers=%d\n" length(cv~>markers))
dbClose(cv)
envSetVal("asimenv.startup" "projectDir" 'string "/home/rocky/work/rh_sram/runs/cadence_netlists")
design("rh_sram_lib" "hphs12t" "schematic" "r")
createNetlist(?recreateAll t)
cv=dbOpenCellViewByType("rh_sram_lib" "tb_hphs12t_seu" "schematic" "schematic" "a")
foreach(inst cv~>instances
  when(equal(inst~>libName "tsmc18rf")
    xy=inst~>xy
    dbCreateLabel(cv list("text" "drawing") list(xCoord(xy)-.55 yCoord(xy)+.8) sprintf(nil "%s  W=%s L=%s" inst~>name inst~>w inst~>l) "lowerLeft" "R0" "stick" .12)
  )
)
rhWireLabel(cv list(list(-2.25 5.3125) list(-2.25 3.1875)) "Q")
rhWireLabel(cv list(list(2.75 5.3125) list(2.75 3.1875)) "QN")
rhWireLabel(cv list(list(-2.25 1.8125) list(-2.25 0.6875)) "S0")
rhWireLabel(cv list(list(2.75 1.8125) list(2.75 0.6875)) "S1")
rhWireLabel(cv list(list(-0.65 3.6125) list(-0.65 1.25) list(-2.25 1.25)) "S0")
rhWireLabel(cv list(list(1.15 3.6125) list(1.15 1.25) list(2.75 1.25)) "S1")
rhWireLabel(cv list(list(-2.25 6.6875) list(-2.25 7.2) list(2.75 7.2) list(2.75 6.6875)) "VDD")
rhWireLabel(cv list(list(-2.25 -0.6875) list(-2.25 -1.2) list(2.75 -1.2) list(2.75 -0.6875)) "VSS")
schCheck(cv)
dbSave(cv)
fprintf(fp "tb_hphs12t_seu markers=%d\n" length(cv~>markers))
dbClose(cv)
envSetVal("asimenv.startup" "projectDir" 'string "/home/rocky/work/rh_sram/runs/cadence_netlists")
design("rh_sram_lib" "tb_hphs12t_seu" "schematic" "r")
createNetlist(?recreateAll t)
cv=dbOpenCellViewByType("rh_sram_lib" "tb_hphs12t_functional" "schematic" "schematic" "a")
foreach(inst cv~>instances
  when(equal(inst~>libName "tsmc18rf")
    xy=inst~>xy
    dbCreateLabel(cv list("text" "drawing") list(xCoord(xy)-.55 yCoord(xy)+.8) sprintf(nil "%s  W=%s L=%s" inst~>name inst~>w inst~>l) "lowerLeft" "R0" "stick" .12)
  )
)
schCheck(cv)
dbSave(cv)
fprintf(fp "tb_hphs12t_functional markers=%d\n" length(cv~>markers))
dbClose(cv)
envSetVal("asimenv.startup" "projectDir" 'string "/home/rocky/work/rh_sram/runs/cadence_netlists")
design("rh_sram_lib" "tb_hphs12t_functional" "schematic" "r")
createNetlist(?recreateAll t)
close(fp)
exit()
