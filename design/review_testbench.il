rhTBWindow=deOpenCellView("rh_sram_lib" "tb_hphs12t_seu" "schematic" "schematic" nil "r")
hiResizeWindow(rhTBWindow list(0:30 1340:900))
hiZoomIn(rhTBWindow geGetWindowCellView(rhTBWindow)~>bBox)
hiRaiseWindow(rhTBWindow)
