procedure(rhWireLabel(cv points name)
  let((w)
    w=schCreateWire(cv "draw" "full" points 0.0625 0.0625 0)
    schCreateWireLabel(cv car(w) car(last(points)) name "lowerLeft" "R0" "stick" 0.09 nil)
  )
)
procedure(rhDevice(cv kind name origin orient width length nets)
  let((master inst point offset finish net term value)
    master=dbOpenCellViewByType("tsmc18rf" if(equal(kind "n") then "nmos2v" else "pmos2v") "symbol" nil "r")
    inst=dbCreateInst(cv master name origin orient)
    dbReplaceProp(inst "w" "string" sprintf(nil "%gu" width))
    dbReplaceProp(inst "l" "string" sprintf(nil "%gu" length))
    dbReplaceProp(inst "m" "string" "1")
    foreach(prop list("ad" "as") dbReplaceProp(inst prop "string" sprintf(nil "%g" width*0.2e-12)))
    foreach(prop list("pd" "ps") dbReplaceProp(inst prop "string" sprintf(nil "%gu" 2*(width+0.2))))
    foreach(term master~>terminals
      net=cadr(assoc(term~>name nets))
      unless(net error("No net supplied for %s.%s" name term~>name))
      point=centerBox(car(term~>pins)~>fig~>bBox)
      offset=cond(
        (equal(term~>name "G") list(-0.625 0.0))
        (equal(term~>name "B") list(0.625 0.0))
        (yCoord(point)>0 list(0.0 0.50))
        (t list(0.0 -0.50))
      )
      finish=list(xCoord(point)+xCoord(offset) yCoord(point)+yCoord(offset))
      point=dbTransformPoint(point inst~>transform)
      finish=dbTransformPoint(finish inst~>transform)
      rhWireLabel(cv list(point finish) net)
    )
    inst
  )
)
procedure(rhPort(cv name direction xy)
  let((master endpoint)
    master=dbOpenCellViewByType("basic" if(equal(direction "input") then "ipin" else "iopin") "symbol" nil "r")
    schCreatePin(cv master name direction nil xy "R0")
    endpoint=list(xCoord(xy)+0.75 yCoord(xy))
    rhWireLabel(cv list(xy endpoint) name)
  )
)
simulator('spectre)
unless(ddGetObj("rh_sram_lib") ddCreateLib("rh_sram_lib" "/home/rocky/work/rh_sram/lib"))
techBindTechFile(ddGetObj("rh_sram_lib") "tsmc18rf")
rhReport=outfile("/home/rocky/work/rh_sram/docs/schematic_connectivity.tsv")

cv=dbOpenCellViewByType("rh_sram_lib" "sram6t" "schematic" "schematic" "w")
foreach(inst cv~>instances dbDeleteObject(inst))
foreach(shape cv~>shapes dbDeleteObject(shape))
foreach(term cv~>terminals dbDeleteObject(term))
foreach(net cv~>nets dbDeleteObject(net))
rhDevice(cv "p" "P1" list(-2.5 3.5) "R0" 0.3 0.18 list(list("D" "Q") list("G" "QN") list("S" "VDD") list("B" "VDD")))
rhDevice(cv "p" "P2" list(2.5 3.5) "R0" 0.3 0.18 list(list("D" "QN") list("G" "Q") list("S" "VDD") list("B" "VDD")))
rhDevice(cv "n" "N1" list(-2.5 0.5) "R0" 0.8 0.18 list(list("D" "Q") list("G" "QN") list("S" "VSS") list("B" "VSS")))
rhDevice(cv "n" "N2" list(2.5 0.5) "R0" 0.8 0.18 list(list("D" "QN") list("G" "Q") list("S" "VSS") list("B" "VSS")))
rhDevice(cv "n" "N3" list(-6 2) "R90" 0.4 0.18 list(list("D" "Q") list("G" "WL") list("S" "BL") list("B" "VSS")))
rhDevice(cv "n" "N4" list(6 2) "R90" 0.4 0.18 list(list("D" "QN") list("G" "WL") list("S" "BLB") list("B" "VSS")))
rhPort(cv "VDD" "inputOutput" list(-8 6))
rhPort(cv "WL" "input" list(-8 5))
rhPort(cv "BL" "inputOutput" list(-8 4))
rhPort(cv "BLB" "inputOutput" list(8 4))
rhPort(cv "VSS" "inputOutput" list(-8 -2))
dbCreateLabel(cv list("text" "drawing") list(-3 6) "SRAM6T  |  180 nm  |  1.8 V" "lowerLeft" "R0" "stick" 0.22)
schCheck(cv)
dbSave(cv)
fprintf(rhReport "CELL	sram6t	%d	MARKERS	%d\n" length(cv~>instances) length(cv~>markers))
foreach(inst cv~>instances
  when(equal(inst~>libName "tsmc18rf")
    foreach(it inst~>instTerms fprintf(rhReport "%s\t%s\t%s\t%s\n" cv~>cellName inst~>name it~>name it~>net~>name))
  )
)
dbClose(cv)
sym=dbOpenCellViewByType("rh_sram_lib" "sram6t" "symbol" "schematicSymbol" "w")
foreach(inst sym~>instances dbDeleteObject(inst))
foreach(shape sym~>shapes dbDeleteObject(shape))
foreach(term sym~>terminals dbDeleteObject(term))
foreach(net sym~>nets dbDeleteObject(net))
dbCreateRect(sym list("device" "drawing") list(list(-1 -1) list(1 1)))
dbCreateLabel(sym list("device" "drawing") list(0 0) "SRAM6T" "centerCenter" "R0" "stick" 0.22)
pinMaster=dbOpenCellViewByType("basic" "sympin" "symbolNN" nil "r")
schCreateSymbolPin(sym pinMaster "BL" "inputOutput" list(-1 0.5) "R0")
schCreateSymbolPin(sym pinMaster "WL" "input" list(-1 0) "R0")
schCreateSymbolPin(sym pinMaster "BLB" "inputOutput" list(-1 -0.5) "R0")
schCreateSymbolPin(sym pinMaster "VDD" "inputOutput" list(0 1) "R270")
schCreateSymbolPin(sym pinMaster "VSS" "inputOutput" list(0 -1) "R90")
dbSave(sym)
dbClose(sym)
cv=dbOpenCellViewByType("rh_sram_lib" "hphs12t" "schematic" "schematic" "w")
foreach(inst cv~>instances dbDeleteObject(inst))
foreach(shape cv~>shapes dbDeleteObject(shape))
foreach(term cv~>terminals dbDeleteObject(term))
foreach(net cv~>nets dbDeleteObject(net))
rhDevice(cv "p" "P1" list(-2.5 6) "R0" 0.3 0.18 list(list("D" "Q") list("G" "QN") list("S" "VDD") list("B" "VDD")))
rhDevice(cv "p" "P2" list(2.5 6) "R0" 0.3 0.18 list(list("D" "QN") list("G" "Q") list("S" "VDD") list("B" "VDD")))
rhDevice(cv "n" "N1" list(-2.5 0) "R0" 2.4 0.18 list(list("D" "S0") list("G" "S1") list("S" "VSS") list("B" "VSS")))
rhDevice(cv "n" "N2" list(2.5 0) "R0" 2.4 0.18 list(list("D" "S1") list("G" "S0") list("S" "VSS") list("B" "VSS")))
rhDevice(cv "n" "N3" list(-2.5 2.5) "R0" 0.8 0.18 list(list("D" "Q") list("G" "S1") list("S" "S0") list("B" "VSS")))
rhDevice(cv "n" "N4" list(2.5 2.5) "R0" 0.8 0.18 list(list("D" "QN") list("G" "S0") list("S" "S1") list("B" "VSS")))
rhDevice(cv "n" "N5" list(-0.9 4.3) "R0" 0.22 0.18 list(list("D" "VDD") list("G" "Q") list("S" "S0") list("B" "VSS")))
rhDevice(cv "n" "N6" list(0.9 4.3) "R0" 0.22 0.18 list(list("D" "VDD") list("G" "QN") list("S" "S1") list("B" "VSS")))
rhDevice(cv "n" "N7" list(-6 1) "R90" 0.4 0.18 list(list("D" "S0") list("G" "WL") list("S" "BL") list("B" "VSS")))
rhDevice(cv "n" "N8" list(6 1) "R90" 0.4 0.18 list(list("D" "S1") list("G" "WL") list("S" "BLB") list("B" "VSS")))
rhDevice(cv "n" "N9" list(-6 4.5) "R90" 0.4 0.18 list(list("D" "Q") list("G" "WL") list("S" "BL") list("B" "VSS")))
rhDevice(cv "n" "N10" list(6 4.5) "R90" 0.4 0.18 list(list("D" "QN") list("G" "WL") list("S" "BLB") list("B" "VSS")))
rhPort(cv "VDD" "inputOutput" list(-8 8))
rhPort(cv "WL" "input" list(-8 7))
rhPort(cv "BL" "inputOutput" list(-8 6))
rhPort(cv "BLB" "inputOutput" list(8 6))
rhPort(cv "VSS" "inputOutput" list(-8 -2))
dbCreateLabel(cv list("text" "drawing") list(-3 8) "HPHS12T  |  180 nm  |  1.8 V" "lowerLeft" "R0" "stick" 0.22)
schCheck(cv)
dbSave(cv)
fprintf(rhReport "CELL	hphs12t	%d	MARKERS	%d\n" length(cv~>instances) length(cv~>markers))
foreach(inst cv~>instances
  when(equal(inst~>libName "tsmc18rf")
    foreach(it inst~>instTerms fprintf(rhReport "%s\t%s\t%s\t%s\n" cv~>cellName inst~>name it~>name it~>net~>name))
  )
)
dbClose(cv)
sym=dbOpenCellViewByType("rh_sram_lib" "hphs12t" "symbol" "schematicSymbol" "w")
foreach(inst sym~>instances dbDeleteObject(inst))
foreach(shape sym~>shapes dbDeleteObject(shape))
foreach(term sym~>terminals dbDeleteObject(term))
foreach(net sym~>nets dbDeleteObject(net))
dbCreateRect(sym list("device" "drawing") list(list(-1 -1) list(1 1)))
dbCreateLabel(sym list("device" "drawing") list(0 0) "HPHS12T" "centerCenter" "R0" "stick" 0.22)
pinMaster=dbOpenCellViewByType("basic" "sympin" "symbolNN" nil "r")
schCreateSymbolPin(sym pinMaster "BL" "inputOutput" list(-1 0.5) "R0")
schCreateSymbolPin(sym pinMaster "WL" "input" list(-1 0) "R0")
schCreateSymbolPin(sym pinMaster "BLB" "inputOutput" list(-1 -0.5) "R0")
schCreateSymbolPin(sym pinMaster "VDD" "inputOutput" list(0 1) "R270")
schCreateSymbolPin(sym pinMaster "VSS" "inputOutput" list(0 -1) "R90")
dbSave(sym)
dbClose(sym)
close(rhReport)
fp=outfile("/home/rocky/work/rh_sram/docs/schematics_done.txt")
fprintf(fp "SCHEMATICS_CREATED\n")
close(fp)
envSetVal("asimenv.startup" "projectDir" 'string "/home/rocky/work/rh_sram/runs/cadence_netlists")
simulator('spectre)
design("rh_sram_lib" "sram6t" "schematic" "r")
netlistPath=createNetlist(?recreateAll t)
printf("NETLIST sram6t %L\n" netlistPath)
envSetVal("asimenv.startup" "projectDir" 'string "/home/rocky/work/rh_sram/runs/cadence_netlists")
simulator('spectre)
design("rh_sram_lib" "hphs12t" "schematic" "r")
netlistPath=createNetlist(?recreateAll t)
printf("NETLIST hphs12t %L\n" netlistPath)
exit()
