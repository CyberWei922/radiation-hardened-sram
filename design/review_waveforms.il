openResults("/home/rocky/work/rh_sram/runs/native/tb_sram6t_seu/psf")
selectResult('tran)
rh6Q=getData("Q")
rh6QN=getData("QN")
openResults("/home/rocky/work/rh_sram/runs/native/tb_hphs12t_seu/psf")
selectResult('tran)
rh12Q=getData("Q")
rh12QN=getData("QN")
rhWaveWindow=awvCreatePlotWindow()
awvPlotWaveform(rhWaveWindow list(rh6Q rh6QN rh12Q rh12QN) ?expr list("6T Q" "6T QN" "HPHS12T Q" "HPHS12T QN"))
hiResizeWindow(rhWaveWindow list(0:30 1610:1090))
