// Device lines exported by Virtuoso from rh_sram_lib schematics.
simulator lang=spectre
subckt sram6t (BL BLB WL VDD VSS)

// rh_sram_lib/sram6t/schematic
P2 (QN Q VDD VDD) pch l=0.18u w=0.3u m=1
P1 (Q QN VDD VDD) pch l=0.18u w=0.3u m=1
N4 (QN WL BLB VSS) nch l=0.18u w=0.4u m=1
N3 (Q WL BL VSS) nch l=0.18u w=0.4u m=1
N2 (QN Q VSS VSS) nch l=0.18u w=0.8u m=1
N1 (Q QN VSS VSS) nch l=0.18u w=0.8u m=1

ends sram6t

subckt hphs12t (BL BLB WL VDD VSS)

// rh_sram_lib/hphs12t/schematic
P2 (QN Q VDD VDD) pch l=0.18u w=0.3u m=1
P1 (Q QN VDD VDD) pch l=0.18u w=0.3u m=1
N10 (QN WL BLB VSS) nch l=0.18u w=0.4u m=1
N9 (Q WL BL VSS) nch l=0.18u w=0.4u m=1
N8 (S1 WL BLB VSS) nch l=0.18u w=0.4u m=1
N7 (S0 WL BL VSS) nch l=0.18u w=0.4u m=1
N6 (VDD QN S1 VSS) nch l=0.18u w=0.22u m=1
N5 (VDD Q S0 VSS) nch l=0.18u w=0.22u m=1
N4 (QN S0 S1 VSS) nch l=0.18u w=0.8u m=1
N3 (Q S1 S0 VSS) nch l=0.18u w=0.8u m=1
N2 (S1 S0 VSS VSS) nch l=0.18u w=2.4u m=1
N1 (S0 S1 VSS VSS) nch l=0.18u w=2.4u m=1

ends hphs12t
