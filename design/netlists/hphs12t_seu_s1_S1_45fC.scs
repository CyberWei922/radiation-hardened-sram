// SEU hold-mode test, stored Q=1, node=S1, charge=45 fC
simulator lang=spectre
global 0
parameters vdd=1.8
include "/home/rocky/work/iclab018um/models/spectre/rf018.scs" section=tt
include "bitcells.scs"
VDD (VDD 0) vsource dc=vdd
VWL (WL 0) vsource type=pwl wave=[ 0 0 2.2e-09 0 2.25e-09 1.8 4.2e-09 1.8 4.25e-09 0 ]
VWE (WE 0) vsource type=pwl wave=[ 0 0 2e-09 0 2.05e-09 1.8 4.4e-09 1.8 4.45e-09 0 ]
VPC (PC 0) vsource type=pwl wave=[ 0 0 1.8e-09 0 1.85e-09 1.8 4.6e-09 1.8 4.65e-09 0 ]
VD (DATA 0) vsource type=pwl wave=[ 0 1.8 ]
VDB (DATAB 0) vsource type=pwl wave=[ 0 0 ]
WBL (BL DATA WE 0) relay ropen=1e12 rclosed=1 vt1=0.8 vt2=1.0
WBLB (BLB DATAB WE 0) relay ropen=1e12 rclosed=1 vt1=0.8 vt2=1.0
PRE1 (BL PC VDD VDD) pch w=2u l=180n
PRE2 (BLB PC VDD VDD) pch w=2u l=180n
CBL (BL 0) capacitor c=100f
CBLB (BLB 0) capacitor c=100f
Xcell (BL BLB WL VDD 0) hphs12t
VSEUMON (Xcell.S1 INJECT) vsource dc=0
ISEU (INJECT 0) isource type=pwl wave=[ 0 0 1e-08 0 1.0002e-08 -1.06936576264e-05 1.0004e-08 -2.0838392444e-05 1.0006e-08 -3.04572991379e-05 1.0008e-08 -3.95725477941e-05 1.001e-08 -4.82054203844e-05 1.0012e-08 -5.63763458177e-05 1.0014e-08 -6.41049336146e-05 1.0016e-08 -7.14100062585e-05 1.0018e-08 -7.83096302756e-05 1.002e-08 -8.48211460934e-05 1.0022e-08 -9.09611967263e-05 1.0024e-08 -9.67457553335e-05 1.0026e-08 -0.000102190151693 1.0028e-08 -0.000107309097638 1.003e-08 -0.000112116711487 1.0032e-08 -0.000116626541523 1.0034e-08 -0.000120851588539 1.0036e-08 -0.000124804327508 1.0038e-08 -0.000128496728389 1.004e-08 -0.000131940276127 1.0042e-08 -0.000135145989857 1.0044e-08 -0.000138124441357 1.0046e-08 -0.000140885772774 1.0048e-08 -0.000143439713656 1.005e-08 -0.000145795597308 1.0052e-08 -0.000147962376507 1.0054e-08 -0.000149948638603 1.0056e-08 -0.000151762620019 1.0058e-08 -0.000153412220183 1.006e-08 -0.000154905014915 1.0062e-08 -0.000156248269281 1.0064e-08 -0.000157448949944 1.0066e-08 -0.000158513737031 1.0068e-08 -0.000159449035527 1.007e-08 -0.000160260986227 1.0072e-08 -0.000160955476251 1.0074e-08 -0.000161538149147 1.0076e-08 -0.000162014414598 1.0078e-08 -0.00016238945774 1.008e-08 -0.000162668248123 1.0082e-08 -0.00016285554831 1.0084e-08 -0.000162955922139 1.0086e-08 -0.000162973742661 1.0088e-08 -0.000162913199768 1.009e-08 -0.000162778307511 1.0092e-08 -0.000162572911138 1.0094e-08 -0.000162300693851 1.0096e-08 -0.000161965183295 1.0098e-08 -0.000161569757794 1.01e-08 -0.000161117652338 1.0102e-08 -0.000160611964338 1.0104e-08 -0.000160055659146 1.0106e-08 -0.000159451575365 1.0108e-08 -0.000158802429944 1.011e-08 -0.000158110823076 1.0112e-08 -0.000157379242898 1.0114e-08 -0.000156610070007 1.0116e-08 -0.000155805581799 1.0118e-08 -0.000154967956634 1.012e-08 -0.000154099277838 1.0122e-08 -0.000153201537545 1.0124e-08 -0.00015227664039 1.0126e-08 -0.00015132640705 1.0128e-08 -0.000150352577653 1.013e-08 -0.000149356815042 1.0132e-08 -0.000148340707922 1.0134e-08 -0.000147305773868 1.0136e-08 -0.000146253462227 1.0138e-08 -0.000145185156895 1.014e-08 -0.000144102178991 1.0142e-08 -0.000143005789418 1.0144e-08 -0.000141897191331 1.0146e-08 -0.000140777532497 1.0148e-08 -0.00013964790757 1.015e-08 -0.000138509360269 1.0152e-08 -0.000137362885477 1.0154e-08 -0.000136209431245 1.0156e-08 -0.000135049900729 1.0158e-08 -0.00013388515404 1.016e-08 -0.000132716010029 1.0162e-08 -0.000131543247988 1.0164e-08 -0.000130367609303 1.0166e-08 -0.000129189799017 1.0168e-08 -0.000128010487354 1.017e-08 -0.000126830311163 1.0172e-08 -0.000125649875318 1.0174e-08 -0.000124469754054 1.0176e-08 -0.000123290492253 1.0178e-08 -0.000122112606678 1.018e-08 -0.000120936587157 1.0182e-08 -0.000119762897721 1.0184e-08 -0.000118591977694 1.0186e-08 -0.000117424242741 1.0188e-08 -0.000116260085874 1.019e-08 -0.000115099878418 1.0192e-08 -0.000113943970938 1.0194e-08 -0.000112792694123 1.0196e-08 -0.000111646359647 1.0198e-08 -0.000110505260983 1.02e-08 -0.000109369674192 1.0202e-08 -0.000108239858673 1.0204e-08 -0.000107116057892 1.0206e-08 -0.000105998500075 1.0208e-08 -0.000104887398874 1.021e-08 -0.000103782954005 1.0212e-08 -0.000102685351865 1.0214e-08 -0.00010159476612 1.0216e-08 -0.000100511358268 1.0218e-08 -9.94352781819e-05 1.022e-08 -9.8366664632e-05 1.0222e-08 -9.7305645781e-05 1.0224e-08 -9.62523396646e-05 1.0226e-08 -9.52068546498e-05 1.0228e-08 -9.41692898756e-05 1.023e-08 -9.31397356746e-05 1.0232e-08 -9.21182739783e-05 1.0234e-08 -9.11049787053e-05 1.0236e-08 -9.00999161337e-05 1.0238e-08 -8.91031452581e-05 1.024e-08 -8.8114718132e-05 1.0242e-08 -8.71346801963e-05 1.0244e-08 -8.61630705935e-05 1.0246e-08 -8.51999224699e-05 1.0248e-08 -8.42452632644e-05 1.025e-08 -8.32991149861e-05 1.0252e-08 -8.23614944796e-05 1.0254e-08 -8.14324136799e-05 1.0256e-08 -8.05118798563e-05 1.0258e-08 -7.95998958464e-05 1.026e-08 -7.86964602798e-05 1.0262e-08 -7.78015677929e-05 1.0264e-08 -7.69152092349e-05 1.0266e-08 -7.6037371864e-05 1.0268e-08 -7.51680395369e-05 1.027e-08 -7.43071928888e-05 1.0272e-08 -7.34548095067e-05 1.0274e-08 -7.26108640953e-05 1.0276e-08 -7.17753286352e-05 1.0278e-08 -7.0948172535e-05 1.028e-08 -7.01293627764e-05 1.0282e-08 -6.93188640539e-05 1.0284e-08 -6.85166389071e-05 1.0286e-08 -6.77226478486e-05 1.0288e-08 -6.69368494858e-05 1.029e-08 -6.61592006374e-05 1.0292e-08 -6.53896564449e-05 1.0294e-08 -6.46281704791e-05 1.0296e-08 -6.38746948422e-05 1.0298e-08 -6.31291802654e-05 1.03e-08 -6.23915762016e-05 1.0302e-08 -6.16618309147e-05 1.0304e-08 -6.09398915648e-05 1.0306e-08 -6.02257042892e-05 1.0308e-08 -5.951921428e-05 1.031e-08 -5.88203658586e-05 1.0312e-08 -5.81291025459e-05 1.0314e-08 -5.74453671302e-05 1.0316e-08 -5.67691017316e-05 1.0318e-08 -5.61002478634e-05 1.032e-08 -5.54387464909e-05 1.0322e-08 -5.47845380871e-05 1.0324e-08 -5.41375626864e-05 1.0326e-08 -5.34977599349e-05 1.0328e-08 -5.28650691394e-05 1.033e-08 -5.22394293129e-05 1.0332e-08 -5.1620779219e-05 1.0334e-08 -5.10090574136e-05 1.0336e-08 -5.04042022845e-05 1.0338e-08 -4.98061520892e-05 1.034e-08 -4.92148449913e-05 1.0342e-08 -4.86302190941e-05 1.0344e-08 -4.80522124733e-05 1.0346e-08 -4.74807632081e-05 1.0348e-08 -4.69158094102e-05 1.035e-08 -4.63572892513e-05 1.0352e-08 -4.58051409901e-05 1.0354e-08 -4.52593029966e-05 1.0356e-08 -4.47197137761e-05 1.0358e-08 -4.41863119913e-05 1.036e-08 -4.36590364836e-05 1.0362e-08 -4.31378262931e-05 1.0364e-08 -4.26226206775e-05 1.0366e-08 -4.21133591296e-05 1.0368e-08 -4.16099813944e-05 1.037e-08 -4.11124274849e-05 1.0372e-08 -4.06206376968e-05 1.0374e-08 -4.01345526227e-05 1.0376e-08 -3.96541131651e-05 1.0378e-08 -3.91792605487e-05 1.038e-08 -3.87099363323e-05 1.0382e-08 -3.82460824189e-05 1.0384e-08 -3.77876410665e-05 1.0386e-08 -3.7334554897e-05 1.0388e-08 -3.68867669055e-05 1.039e-08 -3.64442204676e-05 1.0392e-08 -3.60068593478e-05 1.0394e-08 -3.5574627706e-05 1.0396e-08 -3.51474701039e-05 1.0398e-08 -3.47253315112e-05 1.04e-08 -3.43081573107e-05 1.0402e-08 -3.38958933035e-05 1.0404e-08 -3.34884857133e-05 1.0406e-08 -3.30858811906e-05 1.0408e-08 -3.26880268162e-05 1.041e-08 -3.22948701046e-05 1.0412e-08 -3.19063590068e-05 1.0414e-08 -3.1522441913e-05 1.0416e-08 -3.11430676547e-05 1.0418e-08 -3.07681855063e-05 1.042e-08 -3.03977451872e-05 1.0422e-08 -3.00316968626e-05 1.0424e-08 -2.9669991145e-05 1.0426e-08 -2.93125790943e-05 1.0428e-08 -2.89594122189e-05 1.043e-08 -2.86104424756e-05 1.0432e-08 -2.82656222696e-05 1.0434e-08 -2.79249044546e-05 1.0436e-08 -2.75882423323e-05 1.0438e-08 -2.72555896515e-05 1.044e-08 -2.69269006077e-05 1.0442e-08 -2.6602129842e-05 1.0444e-08 -2.62812324402e-05 1.0446e-08 -2.59641639311e-05 1.0448e-08 -2.56508802856e-05 1.045e-08 -2.53413379147e-05 1.0452e-08 -2.50354936684e-05 1.0454e-08 -2.4733304833e-05 1.0456e-08 -2.44347291303e-05 1.0458e-08 -2.41397247146e-05 1.046e-08 -2.38482501711e-05 1.0462e-08 -2.35602645137e-05 1.0464e-08 -2.32757271822e-05 1.0466e-08 -2.29945980405e-05 1.0468e-08 -2.27168373738e-05 1.047e-08 -2.24424058861e-05 1.0472e-08 -2.21712646976e-05 1.0474e-08 -2.19033753419e-05 1.0476e-08 -2.16386997634e-05 1.0478e-08 -2.13772003145e-05 1.048e-08 -2.11188397526e-05 1.0482e-08 -2.08635812374e-05 1.0484e-08 -2.06113883277e-05 1.0486e-08 -2.03622249788e-05 1.0488e-08 -2.01160555388e-05 1.049e-08 -1.98728447466e-05 1.0492e-08 -1.96325577276e-05 1.0494e-08 -1.93951599916e-05 1.0496e-08 -1.9160617429e-05 1.0498e-08 -1.89288963081e-05 1.05e-08 -1.86999632716e-05 1.0502e-08 -1.84737853335e-05 1.0504e-08 -1.82503298761e-05 1.0506e-08 -1.80295646463e-05 1.0508e-08 -1.78114577529e-05 1.051e-08 -1.75959776631e-05 1.0512e-08 -1.73830931993e-05 1.0514e-08 -1.71727735358e-05 1.0516e-08 -1.69649881956e-05 1.0518e-08 -1.67597070471e-05 1.052e-08 -1.65569003011e-05 1.0522e-08 -1.63565385072e-05 1.0524e-08 -1.61585925506e-05 1.0526e-08 -1.59630336494e-05 1.0528e-08 -1.57698333504e-05 1.053e-08 -1.55789635269e-05 1.0532e-08 -1.53903963747e-05 1.0534e-08 -1.52041044095e-05 1.0536e-08 -1.50200604631e-05 1.0538e-08 -1.48382376808e-05 1.054e-08 -1.46586095179e-05 1.0542e-08 -1.44811497365e-05 1.0544e-08 -1.43058324027e-05 1.0546e-08 -1.4132631883e-05 1.0548e-08 -1.39615228418e-05 1.055e-08 -1.37924802377e-05 1.0552e-08 -1.36254793207e-05 1.0554e-08 -1.34604956292e-05 1.0556e-08 -1.32975049869e-05 1.0558e-08 -1.31364834997e-05 1.056e-08 -1.29774075529e-05 1.0562e-08 -1.2820253808e-05 1.0564e-08 -1.26649991999e-05 1.0566e-08 -1.25116209338e-05 1.0568e-08 -1.23600964825e-05 1.057e-08 -1.22104035832e-05 1.0572e-08 -1.20625202351e-05 1.0574e-08 -1.19164246961e-05 1.0576e-08 -1.177209548e-05 1.0578e-08 -1.1629511354e-05 1.058e-08 -1.14886513356e-05 1.0582e-08 -1.13494946902e-05 1.0584e-08 -1.12120209278e-05 1.0586e-08 -1.10762098008e-05 1.0588e-08 -1.09420413012e-05 1.059e-08 -1.08094956576e-05 1.0592e-08 -1.06785533329e-05 1.0594e-08 -1.05491950218e-05 1.0596e-08 -1.04214016475e-05 1.0598e-08 -1.02951543599e-05 1.06e-08 -1.01704345328e-05 1.0602e-08 -1.00472237611e-05 1.0604e-08 -9.92550385867e-06 1.0606e-08 -9.8052568555e-06 1.0608e-08 -9.68646499559e-06 1.061e-08 -9.56911073431e-06 1.0612e-08 -9.45317673603e-06 1.0614e-08 -9.33864587173e-06 1.0616e-08 -9.22550121665e-06 1.0618e-08 -9.11372604791e-06 1.062e-08 -9.00330384224e-06 1.0622e-08 -8.89421827364e-06 1.0624e-08 -8.78645321113e-06 1.0626e-08 -8.67999271649e-06 1.0628e-08 -8.57482104201e-06 1.063e-08 -8.47092262835e-06 1.0632e-08 -8.36828210229e-06 1.0634e-08 -8.26688427458e-06 1.0636e-08 -8.16671413786e-06 1.0638e-08 -8.06775686446e-06 1.064e-08 -7.96999780437e-06 1.0642e-08 -7.87342248314e-06 1.0644e-08 -7.77801659984e-06 1.0646e-08 -7.68376602503e-06 1.0648e-08 -7.59065679875e-06 1.065e-08 -7.49867512855e-06 1.0652e-08 -7.40780738751e-06 1.0654e-08 -7.3180401123e-06 1.0656e-08 -7.22936000127e-06 1.0658e-08 -7.14175391253e-06 1.066e-08 -7.05520886211e-06 1.0662e-08 -6.96971202205e-06 1.0664e-08 -6.88525071859e-06 1.0666e-08 -6.80181243035e-06 1.0668e-08 -6.71938478654e-06 1.067e-08 -6.63795556516e-06 1.0672e-08 -6.55751269125e-06 1.0674e-08 -6.47804423517e-06 1.0676e-08 -6.39953841083e-06 1.0678e-08 -6.32198357407e-06 1.068e-08 -6.24536822088e-06 1.0682e-08 -6.16968098583e-06 1.0684e-08 -6.09491064036e-06 1.0686e-08 -6.0210460912e-06 1.0688e-08 -5.94807637872e-06 1.069e-08 -5.87599067539e-06 1.0692e-08 -5.80477828415e-06 1.0694e-08 -5.73442863692e-06 1.0696e-08 -5.66493129303e-06 1.0698e-08 -5.59627593769e-06 1.07e-08 -5.52845238052e-06 1.0702e-08 -5.46145055405e-06 1.0704e-08 -5.39526051227e-06 1.0706e-08 -5.32987242915e-06 1.0708e-08 -5.26527659723e-06 1.071e-08 -5.20146342621e-06 1.0712e-08 -5.13842344154e-06 1.0714e-08 -5.07614728302e-06 1.0716e-08 -5.01462570346e-06 1.0718e-08 -4.95384956731e-06 1.072e-08 -4.89380984935e-06 1.0722e-08 -4.83449763332e-06 1.0724e-08 -4.77590411068e-06 1.0726e-08 -4.71802057925e-06 1.0728e-08 -4.66083844199e-06 1.073e-08 -4.60434920572e-06 1.0732e-08 -4.54854447988e-06 1.0734e-08 -4.49341597527e-06 1.0736e-08 -4.43895550288e-06 1.0738e-08 -4.38515497266e-06 1.074e-08 -4.33200639233e-06 1.0742e-08 -4.27950186622e-06 1.0744e-08 -4.22763359411e-06 1.0746e-08 -4.17639387006e-06 1.0748e-08 -4.1257750813e-06 1.075e-08 -4.07576970711e-06 1.0752e-08 -4.02637031771e-06 1.0754e-08 -3.97756957313e-06 1.0756e-08 -3.92936022222e-06 1.0758e-08 -3.88173510146e-06 1.076e-08 -3.83468713403e-06 1.0762e-08 -3.78820932866e-06 1.0764e-08 -3.74229477868e-06 1.0766e-08 -3.69693666094e-06 1.0768e-08 -3.65212823486e-06 1.077e-08 -3.60786284138e-06 1.0772e-08 -3.56413390203e-06 1.0774e-08 -3.52093491792e-06 1.0776e-08 -3.4782594688e-06 1.0778e-08 -3.43610121211e-06 1.078e-08 -3.39445388204e-06 1.0782e-08 -3.35331128861e-06 1.0784e-08 -3.31266731674e-06 1.0786e-08 -3.27251592538e-06 1.0788e-08 -3.23285114657e-06 1.079e-08 -3.1936670846e-06 1.0792e-08 -3.15495791513e-06 1.0794e-08 -3.11671788429e-06 1.0796e-08 -3.0789413079e-06 1.0798e-08 -3.04162257055e-06 1.08e-08 -3.00475612485e-06 1.0802e-08 -2.96833649055e-06 1.0804e-08 -2.93235825373e-06 1.0806e-08 -2.89681606604e-06 1.0808e-08 -2.86170464389e-06 1.081e-08 -2.82701876763e-06 1.0812e-08 -2.79275328085e-06 1.0814e-08 -2.75890308956e-06 1.0816e-08 -2.72546316144e-06 1.0818e-08 -2.69242852513e-06 1.082e-08 -2.65979426946e-06 1.0822e-08 -2.62755554273e-06 1.0824e-08 -2.595707552e-06 1.0826e-08 -2.56424556237e-06 1.0828e-08 -2.5331648963e-06 1.083e-08 -2.50246093288e-06 1.0832e-08 -2.47212910718e-06 1.0834e-08 -2.44216490955e-06 1.0836e-08 -2.41256388495e-06 1.0838e-08 -2.38332163233e-06 1.084e-08 -2.35443380393e-06 1.0842e-08 -2.32589610463e-06 1.0844e-08 -2.29770429138e-06 1.0846e-08 -2.2698541725e-06 1.0848e-08 -2.24234160709e-06 1.085e-08 -2.21516250441e-06 1.0852e-08 -2.18831282327e-06 1.0854e-08 -2.16178857144e-06 1.0856e-08 -2.13558580505e-06 1.0858e-08 -2.10970062802e-06 1.086e-08 -2.08412919145e-06 1.0862e-08 -2.05886769308e-06 1.0864e-08 -2.0339123767e-06 1.0866e-08 -2.00925953162e-06 1.0868e-08 -1.98490549211e-06 1.087e-08 -1.96084663684e-06 1.0872e-08 -1.93707938835e-06 1.0874e-08 -1.91360021253e-06 1.0876e-08 -1.89040561811e-06 1.0878e-08 -1.86749215607e-06 1.088e-08 -1.84485641923e-06 1.0882e-08 -1.82249504166e-06 1.0884e-08 -1.80040469823e-06 1.0886e-08 -1.77858210408e-06 1.0888e-08 -1.75702401417e-06 1.089e-08 -1.73572722278e-06 1.0892e-08 -1.71468856301e-06 1.0894e-08 -1.69390490636e-06 1.0896e-08 -1.67337316223e-06 1.0898e-08 -1.65309027745e-06 1.09e-08 -1.63305323588e-06 1.0902e-08 -1.61325905789e-06 1.0904e-08 -1.5937048e-06 1.0906e-08 -1.57438755436e-06 1.0908e-08 -1.55530444837e-06 1.091e-08 -1.53645264425e-06 1.0912e-08 -1.51782933859e-06 1.0914e-08 -1.49943176195e-06 1.0916e-08 -1.48125717847e-06 1.0918e-08 -1.46330288544e-06 1.092e-08 -1.44556621288e-06 1.0922e-08 -1.42804452319e-06 1.0924e-08 -1.41073521072e-06 1.0926e-08 -1.3936357014e-06 1.0928e-08 -1.37674345235e-06 1.093e-08 -1.36005595152e-06 1.0932e-08 -1.34357071729e-06 1.0934e-08 -1.32728529811e-06 1.0936e-08 -1.31119727215e-06 1.0938e-08 -1.29530424693e-06 1.094e-08 -1.27960385896e-06 1.0942e-08 -1.2640937734e-06 1.0944e-08 -1.24877168368e-06 1.0946e-08 -1.23363531122e-06 1.0948e-08 -1.21868240503e-06 1.095e-08 -1.20391074141e-06 1.0952e-08 -1.18931812361e-06 1.0954e-08 -1.1749023815e-06 1.0956e-08 -1.16066137125e-06 1.0958e-08 -1.146592975e-06 1.096e-08 -1.13269510059e-06 1.0962e-08 -1.11896568118e-06 1.0964e-08 -1.10540267501e-06 1.0966e-08 -1.09200406504e-06 1.0968e-08 -1.07876785868e-06 1.097e-08 -1.06569208751e-06 1.0972e-08 -1.05277480694e-06 1.0974e-08 -1.04001409597e-06 1.0976e-08 -1.02740805686e-06 1.0978e-08 -1.01495481489e-06 1.098e-08 -1.00265251805e-06 1.0982e-08 -9.90499336788e-07 1.0984e-08 -9.78493463705e-07 1.0986e-08 -9.66633113326e-07 1.0988e-08 -9.54916521808e-07 1.099e-08 -9.43341946688e-07 1.0992e-08 -9.31907666621e-07 1.0994e-08 -9.20611981126e-07 1.0996e-08 -9.0945321033e-07 1.0998e-08 -8.98429694721e-07 1.1e-08 -8.87539794902e-07 1.1002e-08 -8.76781891342e-07 1.1004e-08 -8.66154384143e-07 1.1006e-08 -8.55655692796e-07 1.1008e-08 -8.45284255948e-07 1.101e-08 -8.35038531171e-07 1.1012e-08 -8.24916994731e-07 1.1014e-08 -8.14918141363e-07 1.1016e-08 -8.05040484044e-07 1.1018e-08 -7.95282553777e-07 1.102e-08 -7.85642899368e-07 1.1022e-08 -7.76120087213e-07 1.1024e-08 -7.66712701083e-07 1.1026e-08 -7.57419341914e-07 1.1028e-08 -7.48238627601e-07 1.103e-08 -7.39169192788e-07 1.1032e-08 -7.30209688671e-07 1.1034e-08 -7.21358782792e-07 1.1036e-08 -7.12615158844e-07 1.1038e-08 -7.03977516472e-07 1.104e-08 -6.95444571086e-07 1.1042e-08 -6.87015053662e-07 1.1044e-08 -6.7868771056e-07 1.1046e-08 -6.70461303334e-07 1.1048e-08 -6.62334608548e-07 1.105e-08 -6.54306417596e-07 1.1052e-08 -6.46375536519e-07 1.1054e-08 -6.38540785832e-07 1.1056e-08 -6.30801000345e-07 1.1058e-08 -6.2315502899e-07 1.106e-08 -6.15601734653e-07 1.1062e-08 -6.08139994e-07 1.1064e-08 -6.00768697313e-07 1.1066e-08 -5.93486748327e-07 1.1068e-08 -5.86293064061e-07 1.107e-08 -5.79186574663e-07 1.1072e-08 -5.72166223248e-07 1.1074e-08 -5.6523096574e-07 1.1076e-08 -5.58379770719e-07 1.1078e-08 -5.51611619267e-07 1.108e-08 -5.44925504814e-07 1.1082e-08 -5.38320432993e-07 1.1084e-08 -5.31795421488e-07 1.1086e-08 -5.2534949989e-07 1.1088e-08 -5.18981709551e-07 1.109e-08 -5.12691103444e-07 1.1092e-08 -5.0647674602e-07 1.1094e-08 -5.0033771307e-07 1.1096e-08 -4.94273091587e-07 1.1098e-08 -4.88281979629e-07 1.11e-08 -4.8236348619e-07 1.1102e-08 -4.76516731059e-07 1.1104e-08 -4.70740844697e-07 1.1106e-08 -4.65034968105e-07 1.1108e-08 -4.59398252693e-07 1.111e-08 -4.53829860159e-07 1.1112e-08 -4.48328962361e-07 1.1114e-08 -4.42894741195e-07 1.1116e-08 -4.37526388473e-07 1.1118e-08 -4.32223105803e-07 1.112e-08 -4.2698410447e-07 1.1122e-08 -4.2180860532e-07 1.1124e-08 -4.16695838642e-07 1.1126e-08 -4.11645044055e-07 1.1128e-08 -4.06655470394e-07 1.113e-08 -4.01726375599e-07 1.1132e-08 -3.96857026605e-07 1.1134e-08 -3.92046699231e-07 1.1136e-08 -3.87294678076e-07 1.1138e-08 -3.82600256409e-07 1.114e-08 -3.77962736065e-07 1.1142e-08 -3.73381427341e-07 1.1144e-08 -3.68855648896e-07 1.1146e-08 -3.64384727645e-07 1.1148e-08 -3.59967998663e-07 1.115e-08 -3.55604805083e-07 1.1152e-08 -3.51294498002e-07 1.1154e-08 -3.47036436381e-07 1.1156e-08 -3.42829986951e-07 1.1158e-08 -3.38674524119e-07 1.116e-08 -3.34569429875e-07 1.1162e-08 -3.305140937e-07 1.1164e-08 -3.26507912473e-07 1.1166e-08 -3.22550290388e-07 1.1168e-08 -3.18640638855e-07 1.117e-08 -3.14778376423e-07 1.1172e-08 -3.10962928687e-07 1.1174e-08 -3.07193728203e-07 1.1176e-08 -3.03470214407e-07 1.1178e-08 -2.9979183353e-07 1.118e-08 -2.96158038512e-07 1.1182e-08 -2.92568288928e-07 1.1184e-08 -2.890220509e-07 1.1186e-08 -2.85518797023e-07 1.1188e-08 -2.82058006285e-07 1.119e-08 -2.78639163988e-07 1.1192e-08 -2.75261761673e-07 1.1194e-08 -2.71925297044e-07 1.1196e-08 -2.68629273894e-07 1.1198e-08 -2.6537320203e-07 1.12e-08 -2.621565972e-07 1.1202e-08 -2.58978981023e-07 1.1204e-08 -2.55839880915e-07 1.1206e-08 -2.52738830021e-07 1.1208e-08 -2.49675367146e-07 1.121e-08 -2.46649036683e-07 1.1212e-08 -2.43659388547e-07 1.1214e-08 -2.40705978112e-07 1.1216e-08 -2.37788366137e-07 1.1218e-08 -2.34906118709e-07 1.122e-08 -2.32058807171e-07 1.1222e-08 -2.29246008064e-07 1.1224e-08 -2.26467303061e-07 1.1226e-08 -2.23722278906e-07 1.1228e-08 -2.21010527352e-07 1.123e-08 -2.18331645098e-07 1.1232e-08 -2.15685233736e-07 1.1234e-08 -2.13070899684e-07 1.1236e-08 -2.1048825413e-07 1.1238e-08 -2.07936912977e-07 1.124e-08 -2.05416496783e-07 1.1242e-08 -2.02926630705e-07 1.1244e-08 -2.00466944442e-07 1.1246e-08 -1.98037072185e-07 1.1248e-08 -1.95636652555e-07 1.125e-08 -1.93265328556e-07 1.1252e-08 -1.90922747518e-07 1.1254e-08 -1.88608561046e-07 1.1256e-08 -1.86322424968e-07 1.1258e-08 -1.84063999283e-07 1.126e-08 -1.81832948113e-07 1.1262e-08 -1.7962893965e-07 1.1264e-08 -1.77451646107e-07 1.1266e-08 -1.75300743671e-07 1.1268e-08 -1.73175912454e-07 1.127e-08 -1.71076836445e-07 1.1272e-08 -1.69003203465e-07 1.1274e-08 -1.66954705116e-07 1.1276e-08 -1.64931036741e-07 1.1278e-08 -1.62931897373e-07 1.128e-08 -1.60956989696e-07 1.1282e-08 -1.59006019996e-07 1.1284e-08 -1.57078698118e-07 1.1286e-08 -1.55174737427e-07 1.1288e-08 -1.53293854761e-07 1.129e-08 -1.51435770388e-07 1.1292e-08 -1.4960020797e-07 1.1294e-08 -1.47786894517e-07 1.1296e-08 -1.45995560348e-07 1.1298e-08 -1.4422593905e-07 1.13e-08 -1.4247776744e-07 1.1302e-08 -1.40750785527e-07 1.1304e-08 -1.39044736467e-07 1.1306e-08 -1.37359366534e-07 1.1308e-08 -1.35694425073e-07 1.131e-08 -1.3404966447e-07 1.1312e-08 -1.32424840112e-07 1.1314e-08 -1.3081971035e-07 1.1316e-08 -1.29234036465e-07 1.1318e-08 -1.27667582632e-07 1.132e-08 -1.26120115882e-07 1.1322e-08 -1.24591406072e-07 1.1324e-08 -1.23081225849e-07 1.1326e-08 -1.21589350613e-07 1.1328e-08 -1.2011555849e-07 1.133e-08 -1.18659630292e-07 1.1332e-08 -1.1722134949e-07 1.1334e-08 -1.15800502179e-07 1.1336e-08 -1.14396877046e-07 1.1338e-08 -1.13010265341e-07 1.134e-08 -1.11640460842e-07 1.1342e-08 -1.10287259828e-07 1.1344e-08 -1.08950461048e-07 1.1346e-08 -1.0762986569e-07 1.1348e-08 -1.06325277349e-07 1.135e-08 -1.05036502005e-07 1.1352e-08 -1.03763347987e-07 1.1354e-08 -1.02505625948e-07 1.1356e-08 -1.01263148836e-07 1.1358e-08 -1.00035731866e-07 1.136e-08 -9.88231924938e-08 1.1362e-08 -9.76253503869e-08 1.1364e-08 -9.64420273988e-08 1.1366e-08 -9.52730475423e-08 1.1368e-08 -9.41182369635e-08 1.137e-08 -9.29774239156e-08 1.1372e-08 -9.18504387339e-08 1.1374e-08 -9.07371138097e-08 1.1376e-08 -8.96372835664e-08 1.1378e-08 -8.85507844341e-08 1.138e-08 -8.74774548255e-08 1.1382e-08 -8.64171351121e-08 1.1384e-08 -8.53696676001e-08 1.1386e-08 -8.43348965071e-08 1.1388e-08 -8.33126679392e-08 1.139e-08 -8.23028298676e-08 1.1392e-08 -8.13052321063e-08 1.1394e-08 -8.03197262898e-08 1.1396e-08 -7.93461658509e-08 1.1398e-08 -7.83844059988e-08 1.14e-08 -7.7434303698e-08 1.1402e-08 -7.64957176466e-08 1.1404e-08 -7.55685082554e-08 1.1406e-08 -7.46525376271e-08 1.1408e-08 -7.37476695361e-08 1.141e-08 -7.28537694078e-08 1.1412e-08 -7.19707042989e-08 1.1414e-08 -7.10983428774e-08 1.1416e-08 -7.02365554032e-08 1.1418e-08 -6.9385213709e-08 1.142e-08 -6.85441911806e-08 1.1422e-08 -6.7713362739e-08 1.1424e-08 -6.68926048209e-08 1.1426e-08 -6.60817953608e-08 1.1428e-08 -6.5280813773e-08 1.143e-08 -6.44895409332e-08 1.1432e-08 -6.37078591609e-08 1.1434e-08 -6.29356522024e-08 1.1436e-08 -6.21728052128e-08 1.1438e-08 -6.14192047393e-08 1.144e-08 -6.06747387043e-08 1.1442e-08 -5.99392963888e-08 1.1444e-08 -5.92127684156e-08 1.1446e-08 -5.84950467336e-08 1.1448e-08 -5.77860246009e-08 1.145e-08 -5.708559657e-08 1.1452e-08 -5.63936584711e-08 1.1454e-08 -5.57101073973e-08 1.1456e-08 -5.50348416888e-08 1.1458e-08 -5.43677609184e-08 1.146e-08 -5.37087658757e-08 1.1462e-08 -5.30577585533e-08 1.1464e-08 -5.24146421314e-08 1.1466e-08 -5.1779320964e-08 1.1468e-08 -5.11517005643e-08 1.147e-08 -5.05316875908e-08 1.1472e-08 -4.99191898334e-08 1.1474e-08 -4.93141161997e-08 1.1476e-08 -4.87163767015e-08 1.1478e-08 -4.81258824412e-08 1.148e-08 -4.75425455988e-08 1.1482e-08 -4.6966279419e-08 1.1484e-08 -4.63969981976e-08 1.1486e-08 -4.58346172696e-08 1.1488e-08 -4.52790529961e-08 1.149e-08 -4.4730222752e-08 1.1492e-08 -4.41880449137e-08 1.1494e-08 -4.3652438847e-08 1.1496e-08 -4.3123324895e-08 1.1498e-08 -4.26006243664e-08 1.15e-08 -4.20842595238e-08 1.1502e-08 -4.15741535717e-08 1.1504e-08 -4.1070230646e-08 1.1506e-08 -4.05724158016e-08 1.1508e-08 -4.00806350021e-08 1.151e-08 -3.95948151086e-08 1.1512e-08 -3.91148838686e-08 1.1514e-08 -3.86407699051e-08 1.1516e-08 -3.81724027068e-08 1.1518e-08 -3.77097126167e-08 1.152e-08 -3.72526308222e-08 1.1522e-08 -3.68010893448e-08 1.1524e-08 -3.635502103e-08 1.1526e-08 -3.59143595373e-08 1.1528e-08 -3.54790393301e-08 1.153e-08 -3.50489956665e-08 1.1532e-08 -3.46241645891e-08 1.1534e-08 -3.42044829159e-08 1.1536e-08 -3.37898882306e-08 1.1538e-08 -3.33803188734e-08 1.154e-08 -3.29757139322e-08 1.1542e-08 -3.25760132329e-08 1.1544e-08 -3.21811573308e-08 1.1546e-08 -3.17910875019e-08 1.1548e-08 -3.14057457338e-08 1.155e-08 -3.10250747176e-08 1.1552e-08 -3.06490178386e-08 1.1554e-08 -3.02775191686e-08 1.1556e-08 -2.99105234574e-08 1.1558e-08 -2.95479761242e-08 1.156e-08 -2.918982325e-08 1.1562e-08 -2.88360115692e-08 1.1564e-08 -2.84864884621e-08 1.1566e-08 -2.81412019464e-08 1.1568e-08 -2.78001006704e-08 1.157e-08 -2.74631339042e-08 1.1572e-08 -2.71302515335e-08 1.1574e-08 -2.68014040508e-08 1.1576e-08 -2.64765425491e-08 1.1578e-08 -2.61556187141e-08 1.158e-08 -2.5838584817e-08 1.1582e-08 -2.55253937077e-08 1.1584e-08 -2.52159988075e-08 1.1586e-08 -2.49103541023e-08 1.1588e-08 -2.46084141358e-08 1.159e-08 -2.43101340025e-08 1.1592e-08 -2.40154693415e-08 1.1594e-08 -2.37243763294e-08 1.1596e-08 -2.34368116739e-08 1.1598e-08 -2.31527326077e-08 1.16e-08 -2.28720968816e-08 1.1602e-08 -2.25948627588e-08 1.1604e-08 -2.23209890083e-08 1.1606e-08 -2.20504348986e-08 1.1608e-08 -2.17831601923e-08 1.161e-08 -2.15191251396e-08 1.1612e-08 -2.12582904722e-08 1.1614e-08 -2.10006173983e-08 1.1616e-08 -2.07460675958e-08 1.1618e-08 -2.04946032075e-08 1.162e-08 -2.02461868349e-08 1.1622e-08 -2.00007815326e-08 1.1624e-08 -1.97583508035e-08 1.1626e-08 -1.95188585925e-08 1.1628e-08 -1.92822692816e-08 1.163e-08 -1.90485476845e-08 1.1632e-08 -1.88176590417e-08 1.1634e-08 -1.85895690146e-08 1.1636e-08 -1.8364243681e-08 1.1638e-08 -1.81416495299e-08 1.164e-08 -1.79217534565e-08 1.1642e-08 -1.77045227573e-08 1.1644e-08 -1.7489925125e-08 1.1646e-08 -1.7277928644e-08 1.1648e-08 -1.70685017858e-08 1.165e-08 -1.68616134036e-08 1.1652e-08 -1.66572327285e-08 1.1654e-08 -1.64553293644e-08 1.1656e-08 -1.62558732836e-08 1.1658e-08 -1.60588348226e-08 1.166e-08 -1.5864184677e-08 1.1662e-08 -1.56718938982e-08 1.1664e-08 -1.54819338879e-08 1.1666e-08 -1.52942763949e-08 1.1668e-08 -1.51088935101e-08 1.167e-08 -1.49257576629e-08 1.1672e-08 -1.47448416168e-08 1.1674e-08 -1.45661184654e-08 1.1676e-08 -1.43895616286e-08 1.1678e-08 -1.42151448484e-08 1.168e-08 -1.40428421848e-08 1.1682e-08 -1.38726280127e-08 1.1684e-08 -1.37044770172e-08 1.1686e-08 -1.35383641905e-08 1.1688e-08 -1.33742648279e-08 1.169e-08 -1.32121545238e-08 1.1692e-08 -1.3052009169e-08 1.1694e-08 -1.28938049461e-08 1.1696e-08 -1.27375183265e-08 1.1698e-08 -1.25831260668e-08 1.17e-08 -1.24306052054e-08 1.1702e-08 -1.2279933059e-08 1.1704e-08 -1.21310872191e-08 1.1706e-08 -1.1984045549e-08 1.1708e-08 -1.18387861802e-08 1.171e-08 -1.16952875093e-08 1.1712e-08 -1.15535281948e-08 1.1714e-08 -1.14134871539e-08 1.1716e-08 -1.12751435592e-08 1.1718e-08 -1.1138476836e-08 1.172e-08 -1.10034666586e-08 1.1722e-08 -1.08700929481e-08 1.1724e-08 -1.07383358688e-08 1.1726e-08 -1.06081758252e-08 1.1728e-08 -1.04795934598e-08 1.173e-08 -1.03525696492e-08 1.1732e-08 -1.02270855023e-08 1.1734e-08 -1.01031223565e-08 1.1736e-08 -9.98066177586e-09 1.1738e-08 -9.85968554759e-09 1.174e-08 -9.74017567979e-09 1.1742e-08 -9.62211439859e-09 1.1744e-08 -9.5054841456e-09 1.1746e-08 -9.39026757524e-09 1.1748e-08 -9.27644755216e-09 1.175e-08 -9.16400714872e-09 1.1752e-08 -9.05292964248e-09 1.1754e-08 -8.94319851367e-09 1.1756e-08 -8.83479744277e-09 1.1758e-08 -8.72771030805e-09 1.176e-08 -8.62192118322e-09 1.1762e-08 -8.51741433501e-09 1.1764e-08 -8.41417422088e-09 1.1766e-08 -8.31218548666e-09 1.1768e-08 -8.21143296428e-09 1.177e-08 -8.11190166956e-09 1.1772e-08 -8.01357679992e-09 1.1774e-08 -7.91644373219e-09 1.1776e-08 -7.82048802048e-09 1.1778e-08 -7.72569539398e-09 1.178e-08 -7.63205175486e-09 1.1782e-08 -7.53954317617e-09 1.1784e-08 -7.44815589977e-09 1.1786e-08 -7.35787633429e-09 1.1788e-08 -7.26869105309e-09 1.179e-08 -7.18058679229e-09 1.1792e-08 -7.09355044876e-09 1.1794e-08 -7.00756907823e-09 1.1796e-08 -6.92262989328e-09 1.1798e-08 -6.83872026153e-09 1.18e-08 -6.7558277037e-09 1.1802e-08 -6.67393989177e-09 1.1804e-08 -6.59304464715e-09 1.1806e-08 -6.51312993887e-09 1.1808e-08 -6.43418388179e-09 1.181e-08 -6.35619473482e-09 1.1812e-08 -6.27915089921e-09 1.1814e-08 -6.20304091676e-09 1.1816e-08 -6.1278534682e-09 1.1818e-08 -6.05357737142e-09 1.182e-08 -5.98020157987e-09 1.1822e-08 -5.9077151809e-09 1.1824e-08 -5.83610739413e-09 1.1826e-08 -5.76536756984e-09 1.1828e-08 -5.6954851874e-09 1.183e-08 -5.62644985371e-09 1.1832e-08 -5.55825130163e-09 1.1834e-08 -5.49087938849e-09 1.1836e-08 -5.42432409453e-09 1.1838e-08 -5.35857552148e-09 1.184e-08 -5.29362389101e-09 1.1842e-08 -5.22945954333e-09 1.1844e-08 -5.16607293574e-09 1.1846e-08 -5.10345464121e-09 1.1848e-08 -5.04159534695e-09 1.185e-08 -4.98048585308e-09 1.1852e-08 -4.92011707123e-09 1.1854e-08 -4.86048002318e-09 1.1856e-08 -4.80156583953e-09 1.1858e-08 -4.7433657584e-09 1.186e-08 -4.68587112411e-09 1.1862e-08 -4.62907338589e-09 1.1864e-08 -4.57296409663e-09 1.1866e-08 -4.51753491158e-09 1.1868e-08 -4.46277758717e-09 1.187e-08 -4.40868397973e-09 1.1872e-08 -4.3552460443e-09 1.1874e-08 -4.30245583344e-09 1.1876e-08 -4.25030549604e-09 1.1878e-08 -4.19878727616e-09 1.188e-08 -4.14789351186e-09 1.1882e-08 -4.09761663407e-09 1.1884e-08 -4.04794916547e-09 1.1886e-08 -3.99888371938e-09 1.1888e-08 -3.95041299865e-09 1.189e-08 -3.90252979457e-09 1.1892e-08 -3.85522698581e-09 1.1894e-08 -3.80849753736e-09 1.1896e-08 -3.7623344995e-09 1.1898e-08 -3.71673100672e-09 1.19e-08 -3.67168027673e-09 1.1902e-08 -3.62717560948e-09 1.1904e-08 -3.58321038609e-09 1.1906e-08 -3.53977806794e-09 1.1908e-08 -3.49687219564e-09 1.191e-08 -3.45448638812e-09 1.1912e-08 -3.41261434163e-09 1.1914e-08 -3.37124982885e-09 1.1916e-08 -3.33038669792e-09 1.1918e-08 -3.29001887157e-09 1.192e-08 -3.25014034618e-09 1.1922e-08 -3.2107451909e-09 1.1924e-08 -3.17182754677e-09 1.1926e-08 -3.13338162586e-09 1.1928e-08 -3.09540171036e-09 1.193e-08 -3.0578821518e-09 1.1932e-08 -3.02081737017e-09 1.1934e-08 -2.98420185309e-09 1.1936e-08 -2.94803015499e-09 1.1938e-08 -2.91229689631e-09 1.194e-08 -2.87699676271e-09 1.1942e-08 -2.84212450424e-09 1.1944e-08 -2.80767493461e-09 1.1946e-08 -2.77364293038e-09 1.1948e-08 -2.74002343021e-09 1.195e-08 -2.70681143411e-09 1.1952e-08 -2.6740020027e-09 1.1954e-08 -2.64159025647e-09 1.1956e-08 -2.60957137505e-09 1.1958e-08 -2.5779405965e-09 1.196e-08 -2.54669321661e-09 1.1962e-08 -2.51582458817e-09 1.1964e-08 -2.48533012032e-09 1.1966e-08 -2.45520527782e-09 1.1968e-08 -2.42544558044e-09 1.197e-08 -2.39604660222e-09 1.1972e-08 -2.36700397085e-09 1.1974e-08 -2.33831336705e-09 1.1976e-08 -2.30997052386e-09 1.1978e-08 -2.28197122605e-09 1.198e-08 -2.25431130948e-09 1.1982e-08 -2.22698666051e-09 1.1984e-08 -2.19999321532e-09 1.1986e-08 -2.17332695937e-09 1.1988e-08 -2.14698392679e-09 1.199e-08 -2.12096019976e-09 1.1992e-08 -2.09525190796e-09 1.1994e-08 -2.06985522798e-09 1.1996e-08 -2.04476638275e-09 1.1998e-08 -2.01998164099e-09 1.2e-08 -1.99549731664e-09 1.2002e-08 -1.97130976833e-09 1.2004e-08 -1.94741539881e-09 1.2006e-08 -1.92381065444e-09 1.2008e-08 -1.90049202466e-09 1.201e-08 -1.87745604146e-09 1.2012e-08 -1.85469927886e-09 1.2014e-08 -1.83221835241e-09 1.2016e-08 -1.81000991867e-09 1.2018e-08 -1.78807067476e-09 1.202e-08 -1.7663973578e-09 1.2022e-08 -1.74498674448e-09 1.2024e-08 -1.72383565055e-09 1.2026e-08 -1.70294093035e-09 1.2028e-08 -1.68229947637e-09 1.203e-08 -1.66190821875e-09 1.2032e-08 -1.64176412485e-09 1.2034e-08 -1.62186419877e-09 1.2036e-08 -1.60220548095e-09 1.2038e-08 -1.58278504768e-09 1.204e-08 -1.5636000107e-09 1.2042e-08 -1.54464751676e-09 1.2044e-08 -1.52592474719e-09 1.2046e-08 -1.50742891748e-09 1.2048e-08 -1.48915727689e-09 1.205e-08 -1.471107108e-09 1.2052e-08 -1.45327572635e-09 1.2054e-08 -1.43566047998e-09 1.2056e-08 -1.41825874913e-09 1.2058e-08 -1.40106794575e-09 1.206e-08 -1.38408551318e-09 1.2062e-08 -1.36730892574e-09 1.2064e-08 -1.35073568837e-09 1.2066e-08 -1.33436333625e-09 1.2068e-08 -1.31818943444e-09 1.207e-08 -1.30221157751e-09 1.2072e-08 -1.28642738918e-09 1.2074e-08 -1.270834522e-09 1.2076e-08 -1.25543065694e-09 1.2078e-08 -1.24021350309e-09 1.208e-08 -1.22518079732e-09 1.2082e-08 -1.21033030392e-09 1.2084e-08 -1.19565981428e-09 1.2086e-08 -1.18116714658e-09 1.2088e-08 -1.1668501454e-09 1.209e-08 -1.1527066815e-09 1.2092e-08 -1.13873465141e-09 1.2094e-08 -1.12493197718e-09 1.2096e-08 -1.11129660602e-09 1.2098e-08 -1.09782651006e-09 1.21e-08 -1.08451968598e-09 1.2102e-08 -1.07137415474e-09 1.2104e-08 -1.05838796132e-09 1.2106e-08 -1.04555917436e-09 1.2108e-08 -1.03288588594e-09 1.211e-08 -1.02036621124e-09 1.2112e-08 -1.0079982883e-09 1.2114e-08 -9.95780277737e-10 1.2116e-08 -9.83710362445e-10 1.2118e-08 -9.71786747354e-10 1.212e-08 -9.60007659151e-10 1.2122e-08 -9.48371346016e-10 1.2124e-08 -9.36876077363e-10 1.2126e-08 -9.25520143583e-10 1.2128e-08 -9.1430185579e-10 1.213e-08 -9.03219545568e-10 1.2132e-08 -8.92271564725e-10 1.2134e-08 -8.81456285045e-10 1.2136e-08 -8.70772098049e-10 1.2138e-08 -8.60217414755e-10 1.214e-08 -8.4979066544e-10 1.2142e-08 -8.39490299408e-10 1.2144e-08 -8.2931478476e-10 1.2146e-08 -8.19262608164e-10 1.2148e-08 -8.09332274632e-10 1.215e-08 -7.99522307297e-10 1.2152e-08 -7.89831247191e-10 1.2154e-08 -7.80257653034e-10 1.2156e-08 -7.70800101013e-10 1.2158e-08 -7.61457184575e-10 1.216e-08 -7.52227514213e-10 1.2162e-08 -7.43109717265e-10 1.2164e-08 -7.34102437707e-10 1.2166e-08 -7.2520433595e-10 1.2168e-08 -7.16414088643e-10 1.217e-08 -7.07730388477e-10 1.2172e-08 -6.99151943985e-10 1.2174e-08 -6.90677479358e-10 1.2176e-08 -6.82305734248e-10 1.2178e-08 -6.74035463588e-10 1.218e-08 -6.65865437397e-10 1.2182e-08 -6.57794440607e-10 1.2184e-08 -6.49821272876e-10 1.2186e-08 -6.41944748411e-10 1.2188e-08 -6.34163695795e-10 1.219e-08 -6.26476957806e-10 1.2192e-08 -6.18883391251e-10 1.2194e-08 -6.11381866793e-10 1.2196e-08 -6.03971268785e-10 1.2198e-08 -5.966504951e-10 1.22e-08 -5.89418456973e-10 1.2202e-08 -5.82274078834e-10 1.2204e-08 -5.75216298151e-10 1.2206e-08 -5.68244065272e-10 1.2208e-08 -5.61356343265e-10 1.221e-08 -5.54552107769e-10 1.2212e-08 -5.47830346839e-10 1.2214e-08 -5.41190060795e-10 1.2216e-08 -5.34630262076e-10 1.2218e-08 -5.28149975089e-10 1.222e-08 -5.21748236067e-10 1.2222e-08 -5.15424092927e-10 1.2224e-08 -5.09176605122e-10 1.2226e-08 -5.0300484351e-10 1.2228e-08 -4.96907890208e-10 1.223e-08 -4.90884838459e-10 1.2232e-08 -4.849347925e-10 1.2234e-08 -4.79056867421e-10 1.2236e-08 -4.73250189041e-10 1.2238e-08 -4.67513893774e-10 1.224e-08 -4.61847128503e-10 1.2242e-08 -4.56249050449e-10 1.2244e-08 -4.50718827052e-10 1.2246e-08 -4.45255635839e-10 1.2248e-08 -4.3985866431e-10 1.225e-08 -4.34527109812e-10 1.2252e-08 -4.29260179421e-10 1.2254e-08 -4.24057089825e-10 1.2256e-08 -4.18917067203e-10 1.2258e-08 -4.13839347119e-10 1.226e-08 -4.088231744e-10 1.2262e-08 -4.03867803024e-10 1.2264e-08 -3.98972496017e-10 1.2266e-08 -3.94136525333e-10 1.2268e-08 -3.89359171753e-10 1.227e-08 -3.84639724776e-10 1.2272e-08 -3.79977482513e-10 1.2274e-08 -3.75371751581e-10 1.2276e-08 -3.70821847002e-10 1.2278e-08 -3.66327092103e-10 1.228e-08 -3.61886818411e-10 1.2282e-08 -3.57500365554e-10 1.2284e-08 -3.53167081169e-10 1.2286e-08 -3.48886320795e-10 1.2288e-08 -3.44657447787e-10 1.229e-08 -3.40479833214e-10 1.2292e-08 -3.3635285577e-10 1.2294e-08 -3.32275901679e-10 1.2296e-08 -3.28248364604e-10 1.2298e-08 -3.24269645559e-10 1.23e-08 -3.20339152818e-10 1.2302e-08 -3.16456301826e-10 1.2304e-08 -3.12620515115e-10 1.2306e-08 -3.08831222215e-10 1.2308e-08 -3.05087859573e-10 1.231e-08 -3.01389870464e-10 1.2312e-08 -2.97736704914e-10 1.2314e-08 -2.94127819612e-10 1.2316e-08 -2.90562677837e-10 1.2318e-08 -2.87040749368e-10 1.232e-08 -2.83561510416e-10 1.2322e-08 -2.80124443537e-10 1.2324e-08 -2.76729037562e-10 1.2326e-08 -2.73374787517e-10 1.2328e-08 -2.70061194546e-10 1.233e-08 -2.66787765844e-10 1.2332e-08 -2.63554014578e-10 1.2334e-08 -2.60359459813e-10 1.2336e-08 -2.57203626447e-10 1.2338e-08 -2.54086045136e-10 1.234e-08 -2.51006252223e-10 1.2342e-08 -2.47963789674e-10 1.2344e-08 -2.44958205005e-10 1.2346e-08 -2.41989051216e-10 1.2348e-08 -2.39055886727e-10 1.235e-08 -2.36158275309e-10 1.2352e-08 -2.3329578602e-10 1.2354e-08 -2.30467993144e-10 1.2356e-08 -2.27674476124e-10 1.2358e-08 -2.24914819498e-10 1.236e-08 -2.22188612844e-10 1.2362e-08 -2.19495450712e-10 1.2364e-08 -2.16834932567e-10 1.2366e-08 -2.1420666273e-10 1.2368e-08 -2.11610250317e-10 1.237e-08 -2.09045309181e-10 1.2372e-08 -2.06511457858e-10 1.2374e-08 -2.04008319507e-10 1.2376e-08 -2.01535521852e-10 1.2378e-08 -1.99092697133e-10 1.238e-08 -1.96679482046e-10 1.2382e-08 -1.9429551769e-10 1.2384e-08 -1.91940449517e-10 1.2386e-08 -1.89613927272e-10 1.2388e-08 -1.8731560495e-10 1.239e-08 -1.85045140737e-10 1.2392e-08 -1.82802196963e-10 1.2394e-08 -1.80586440052e-10 1.2396e-08 -1.78397540469e-10 1.2398e-08 -1.76235172676e-10 1.24e-08 -1.74099015079e-10 1.2402e-08 -1.71988749982e-10 1.2404e-08 -1.6990406354e-10 1.2406e-08 -1.67844645714e-10 1.2408e-08 -1.65810190221e-10 1.241e-08 -1.63800394491e-10 1.2412e-08 -1.61814959621e-10 1.2414e-08 -1.59853590332e-10 1.2416e-08 -1.57915994923e-10 1.2418e-08 -1.56001885229e-10 1.242e-08 -1.5411097658e-10 1.2422e-08 -1.52242987753e-10 1.2424e-08 -1.50397640936e-10 1.2426e-08 -1.48574661684e-10 1.2428e-08 -1.46773778877e-10 1.243e-08 -1.44994724685e-10 1.2432e-08 -1.4323723452e-10 1.2434e-08 -1.41501047003e-10 1.2436e-08 -1.39785903925e-10 1.2438e-08 -1.38091550203e-10 1.244e-08 -1.36417733849e-10 1.2442e-08 -1.34764205929e-10 1.2444e-08 -1.33130720524e-10 1.2446e-08 -1.31517034699e-10 1.2448e-08 -1.29922908461e-10 1.245e-08 -1.28348104727e-10 1.2452e-08 -1.26792389288e-10 1.2454e-08 -1.25255530773e-10 1.2456e-08 -1.23737300617e-10 1.2458e-08 -1.22237473024e-10 1.246e-08 -1.20755824936e-10 1.2462e-08 -1.19292135997e-10 1.2464e-08 -1.17846188524e-10 1.2466e-08 -1.16417767471e-10 1.2468e-08 -1.15006660399e-10 1.247e-08 -1.13612657445e-10 1.2472e-08 -1.12235551288e-10 1.2474e-08 -1.10875137121e-10 1.2476e-08 -1.0953121262e-10 1.2478e-08 -1.08203577912e-10 1.248e-08 -1.06892035548e-10 1.2482e-08 -1.05596390471e-10 1.2484e-08 -1.04316449989e-10 1.2486e-08 -1.03052023747e-10 1.2488e-08 -1.01802923694e-10 1.249e-08 -1.00568964062e-10 1.2492e-08 -9.93499613318e-11 1.2494e-08 -9.81457342102e-11 1.2496e-08 -9.69561036013e-11 1.2498e-08 -9.57808925796e-11 1.25e-08 -9.46199263646e-11 1.2502e-08 -9.3473032294e-11 1.2504e-08 -9.23400397985e-11 1.2506e-08 -9.12207803762e-11 1.2508e-08 -9.01150875676e-11 1.251e-08 -8.9022796931e-11 1.2512e-08 -8.79437460178e-11 1.2514e-08 -8.68777743485e-11 1.2516e-08 -8.58247233888e-11 1.2518e-08 -8.47844365259e-11 1.252e-08 -8.37567590454e-11 1.2522e-08 -8.27415381082e-11 1.2524e-08 -8.17386227277e-11 1.2526e-08 -8.07478637476e-11 1.2528e-08 -7.97691138193e-11 1.253e-08 -7.88022273803e-11 1.2532e-08 -7.78470606326e-11 1.2534e-08 -7.69034715211e-11 1.2536e-08 -7.59713197124e-11 1.2538e-08 -7.50504665744e-11 1.254e-08 -7.41407751551e-11 1.2542e-08 -7.32421101626e-11 1.2544e-08 -7.23543379449e-11 1.2546e-08 -7.14773264701e-11 1.2548e-08 -7.06109453064e-11 1.255e-08 -6.97550656032e-11 1.2552e-08 -6.89095600717e-11 1.2554e-08 -6.80743029658e-11 1.2556e-08 -6.72491700638e-11 1.2558e-08 -6.64340386495e-11 1.256e-08 -6.56287874942e-11 1.2562e-08 -6.48332968388e-11 1.2564e-08 -6.40474483756e-11 1.2566e-08 -6.3271125231e-11 1.2568e-08 -6.2504211948e-11 1.257e-08 -6.1746594469e-11 1.2572e-08 -6.09981601191e-11 1.2574e-08 -6.0258797589e-11 1.2576e-08 -5.95283969185e-11 1.2578e-08 -5.88068494804e-11 1.258e-08 -5.80940479642e-11 1.2582e-08 -5.73898863599e-11 1.2584e-08 -5.66942599426e-11 1.2586e-08 -5.60070652569e-11 1.2588e-08 -5.53282001011e-11 1.259e-08 -5.46575635124e-11 1.2592e-08 -5.3995055752e-11 1.2594e-08 -5.33405782898e-11 1.2596e-08 -5.269403379e-11 1.2598e-08 -5.20553260967e-11 1.26e-08 -5.14243602194e-11 1.2602e-08 -5.08010423192e-11 1.2604e-08 -5.01852796944e-11 1.2606e-08 -4.95769807671e-11 1.2608e-08 -4.89760550692e-11 1.261e-08 -4.83824132295e-11 1.2612e-08 -4.77959669598e-11 1.2614e-08 -4.72166290422e-11 1.2616e-08 -4.66443133159e-11 1.2618e-08 -4.60789346644e-11 1.262e-08 -4.55204090031e-11 1.2622e-08 -4.49686532664e-11 1.2624e-08 -4.44235853957e-11 1.2626e-08 -4.38851243268e-11 1.2628e-08 -4.33531899784e-11 1.263e-08 -4.28277032396e-11 1.2632e-08 -4.23085859586e-11 1.2634e-08 -4.17957609308e-11 1.2636e-08 -4.12891518873e-11 1.2638e-08 -4.07886834839e-11 1.264e-08 -4.02942812894e-11 1.2642e-08 -3.9805871775e-11 1.2644e-08 -3.9323382303e-11 1.2646e-08 -3.88467411162e-11 1.2648e-08 -3.83758773271e-11 1.265e-08 -3.79107209076e-11 1.2652e-08 -3.74512026783e-11 1.2654e-08 -3.69972542983e-11 1.2656e-08 -3.65488082551e-11 1.2658e-08 -3.61057978546e-11 1.266e-08 -3.5668157211e-11 1.2662e-08 -3.52358212371e-11 1.2664e-08 -3.48087256347e-11 1.2666e-08 -3.43868068849e-11 1.2668e-08 -3.39700022388e-11 1.267e-08 -3.3558249708e-11 1.2672e-08 -3.31514880555e-11 1.2674e-08 -3.27496567865e-11 1.2676e-08 -3.23526961396e-11 1.2678e-08 -3.19605470776e-11 1.268e-08 -3.1573151279e-11 1.2682e-08 -3.11904511292e-11 1.2684e-08 -3.0812389712e-11 1.2686e-08 -3.04389108009e-11 1.2688e-08 -3.00699588512e-11 1.269e-08 -2.97054789913e-11 1.2692e-08 -2.93454170146e-11 1.2694e-08 -2.89897193717e-11 1.2696e-08 -2.86383331624e-11 1.2698e-08 -2.82912061273e-11 1.27e-08 -2.79482866409e-11 1.2702e-08 -2.7609523703e-11 1.2704e-08 -2.72748669321e-11 1.2706e-08 -2.69442665568e-11 1.2708e-08 -2.66176734095e-11 1.271e-08 -2.62950389182e-11 1.2712e-08 -2.59763150999e-11 1.2714e-08 -2.5661454553e-11 1.2716e-08 -2.53504104505e-11 1.2718e-08 -2.50431365332e-11 1.272e-08 -2.47395871023e-11 1.2722e-08 -2.44397170131e-11 1.2724e-08 -2.41434816681e-11 1.2726e-08 -2.38508370104e-11 1.2728e-08 -2.35617395169e-11 1.273e-08 -2.32761461923e-11 1.2732e-08 -2.29940145623e-11 1.2734e-08 -2.27153026675e-11 1.2736e-08 -2.24399690571e-11 1.2738e-08 -2.21679727827e-11 1.274e-08 -2.18992733922e-11 1.2742e-08 -2.16338309239e-11 1.2744e-08 -2.13716059005e-11 1.2746e-08 -2.1112559323e-11 1.2748e-08 -2.08566526653e-11 1.275e-08 -2.06038478683e-11 1.2752e-08 -2.03541073342e-11 1.2754e-08 -2.01073939207e-11 1.2756e-08 -1.98636709361e-11 1.2758e-08 -1.9622902133e-11 1.276e-08 -1.93850517037e-11 1.2762e-08 -1.91500842744e-11 1.2764e-08 -1.89179649001e-11 1.2766e-08 -1.86886590593e-11 1.2768e-08 -1.8462132649e-11 1.277e-08 -1.82383519796e-11 1.2772e-08 -1.80172837696e-11 1.2774e-08 -1.77988951414e-11 1.2776e-08 -1.75831536154e-11 1.2778e-08 -1.7370027106e-11 1.278e-08 -1.71594839165e-11 1.2782e-08 -1.69514927341e-11 1.2784e-08 -1.6746022626e-11 1.2786e-08 -1.65430430339e-11 1.2788e-08 -1.63425237702e-11 1.279e-08 -1.61444350131e-11 1.2792e-08 -1.59487473022e-11 1.2794e-08 -1.57554315344e-11 1.2796e-08 -1.55644589592e-11 1.2798e-08 -1.53758011746e-11 1.28e-08 -1.51894301228e-11 1.2802e-08 -1.50053180862e-11 1.2804e-08 -1.48234376832e-11 1.2806e-08 -1.46437618639e-11 1.2808e-08 -1.44662639066e-11 1.281e-08 -1.42909174131e-11 1.2812e-08 -1.41176963056e-11 1.2814e-08 -1.39465748219e-11 1.2816e-08 -1.37775275125e-11 1.2818e-08 -1.36105292361e-11 1.282e-08 -1.34455551564e-11 1.2822e-08 -1.32825807378e-11 1.2824e-08 -1.31215817424e-11 1.2826e-08 -1.29625342259e-11 1.2828e-08 -1.28054145344e-11 1.283e-08 -1.26501993005e-11 1.2832e-08 -1.24968654402e-11 1.2834e-08 -1.23453901493e-11 1.2836e-08 -1.21957508999e-11 1.2838e-08 -1.20479254372e-11 1.284e-08 -1.19018917762e-11 1.2842e-08 -1.17576281984e-11 1.2844e-08 -1.16151132485e-11 1.2846e-08 -1.14743257313e-11 1.2848e-08 -1.13352447084e-11 1.285e-08 -1.11978494953e-11 1.2852e-08 -1.10621196582e-11 1.2854e-08 -1.0928035011e-11 1.2856e-08 -1.07955756123e-11 1.2858e-08 -1.06647217622e-11 1.286e-08 -1.05354539999e-11 1.2862e-08 -1.04077531002e-11 1.2864e-08 -1.02816000711e-11 1.2866e-08 -1.01569761509e-11 1.2868e-08 -1.0033862805e-11 1.287e-08 -9.9122417237e-12 1.2872e-08 -9.79209481917e-12 1.2874e-08 -9.67340422282e-12 1.2876e-08 -9.55615228265e-12 1.2878e-08 -9.4403215606e-12 1.288e-08 -9.32589483001e-12 1.2882e-08 -9.21285507301e-12 1.2884e-08 -9.10118547801e-12 1.2886e-08 -8.99086943718e-12 1.2888e-08 -8.88189054401e-12 1.289e-08 -8.77423259085e-12 1.2892e-08 -8.6678795665e-12 1.2894e-08 -8.56281565384e-12 1.2896e-08 -8.45902522746e-12 1.2898e-08 -8.35649285136e-12 1.29e-08 -8.25520327663e-12 1.2902e-08 -8.1551414392e-12 1.2904e-08 -8.05629245759e-12 1.2906e-08 -7.95864163069e-12 1.2908e-08 -7.8621744356e-12 1.291e-08 -7.76687652543e-12 1.2912e-08 -7.67273372723e-12 1.2914e-08 -7.57973203979e-12 1.2916e-08 -7.48785763165e-12 1.2918e-08 -7.39709683898e-12 1.292e-08 -7.30743616358e-12 1.2922e-08 -7.21886227085e-12 1.2924e-08 -7.13136198785e-12 1.2926e-08 -7.04492230127e-12 1.2928e-08 -6.95953035556e-12 1.293e-08 -6.87517345098e-12 1.2932e-08 -6.79183904175e-12 1.2934e-08 -6.70951473413e-12 1.2936e-08 -6.6281882846e-12 1.2938e-08 -6.54784759809e-12 1.294e-08 -6.46848072608e-12 1.2942e-08 -6.39007586491e-12 1.2944e-08 -6.31262135398e-12 1.2946e-08 -6.23610567405e-12 1.2948e-08 -6.16051744548e-12 1.295e-08 -6.08584542658e-12 1.2952e-08 -6.01207851191e-12 1.2954e-08 -5.93920573064e-12 1.2956e-08 -5.86721624494e-12 1.2958e-08 -5.79609934831e-12 1.296e-08 -5.72584446405e-12 1.2962e-08 -5.65644114366e-12 1.2964e-08 -5.58787906527e-12 1.2966e-08 -5.52014803214e-12 1.2968e-08 -5.45323797112e-12 1.297e-08 -5.38713893115e-12 1.2972e-08 -5.3218410818e-12 1.2974e-08 -5.25733471178e-12 1.2976e-08 -5.19361022752e-12 1.2978e-08 -5.13065815174e-12 1.298e-08 -5.06846912202e-12 1.2982e-08 -5.00703388944e-12 1.2984e-08 -4.94634331717e-12 1.2986e-08 -4.88638837914e-12 1.2988e-08 -4.82716015868e-12 1.299e-08 -4.7686498472e-12 1.2992e-08 -4.71084874288e-12 1.2994e-08 -4.65374824937e-12 1.2996e-08 -4.59733987454e-12 1.2998e-08 -4.54161522916e-12 1.3e-08 -4.4865660257e-12 1.3002e-08 -4.4321840771e-12 1.3004e-08 -4.37846129551e-12 1.3006e-08 -4.32538969114e-12 1.3008e-08 -4.27296137101e-12 1.301e-08 -4.22116853785e-12 1.3012e-08 -4.17000348886e-12 1.3014e-08 -4.11945861466e-12 1.3016e-08 -4.06952639804e-12 1.3018e-08 -4.02019941296e-12 1.302e-08 -3.97147032337e-12 1.3022e-08 -3.92333188213e-12 1.3024e-08 -3.87577692995e-12 1.3026e-08 -3.82879839435e-12 1.3028e-08 -3.78238928852e-12 1.303e-08 -3.73654271038e-12 1.3032e-08 -3.69125184149e-12 1.3034e-08 -3.64650994607e-12 1.3036e-08 -3.60231036998e-12 1.3038e-08 -3.55864653972e-12 1.304e-08 -3.51551196149e-12 1.3042e-08 -3.47290022019e-12 1.3044e-08 -3.43080497849e-12 1.3046e-08 -3.38921997585e-12 1.3048e-08 -3.34813902765e-12 1.305e-08 -3.30755602419e-12 1.3052e-08 -3.26746492987e-12 1.3054e-08 -3.22785978223e-12 1.3056e-08 -3.18873469106e-12 1.3058e-08 -3.15008383759e-12 1.306e-08 -3.11190147353e-12 1.3062e-08 -3.07418192031e-12 1.3064e-08 -3.03691956816e-12 1.3066e-08 -3.00010887533e-12 1.3068e-08 -2.96374436721e-12 1.307e-08 -2.92782063558e-12 1.3072e-08 -2.89233233776e-12 1.3074e-08 -2.85727419582e-12 1.3076e-08 -2.82264099583e-12 1.3078e-08 -2.78842758703e-12 1.308e-08 -2.7546288811e-12 1.3082e-08 -2.72123985141e-12 1.3084e-08 -2.68825553225e-12 1.3086e-08 -2.65567101809e-12 1.3088e-08 -2.62348146288e-12 1.309e-08 -2.59168207929e-12 1.3092e-08 -2.56026813802e-12 1.3094e-08 -2.5292349671e-12 1.3096e-08 -2.49857795121e-12 1.3098e-08 -2.46829253092e-12 1.31e-08 -2.43837420212e-12 1.3102e-08 -2.40881851526e-12 1.3104e-08 -2.37962107474e-12 1.3106e-08 -2.35077753822e-12 1.3108e-08 -2.32228361603e-12 1.311e-08 -2.29413507046e-12 1.3112e-08 -2.26632771517e-12 1.3114e-08 -2.23885741459e-12 1.3116e-08 -2.21172008324e-12 1.3118e-08 -2.18491168519e-12 1.312e-08 -2.15842823342e-12 1.3122e-08 -2.13226578923e-12 1.3124e-08 -2.10642046167e-12 1.3126e-08 -2.08088840695e-12 1.3128e-08 -2.05566582787e-12 1.313e-08 -2.03074897325e-12 1.3132e-08 -2.00613413739e-12 1.3134e-08 -1.9818176595e-12 1.3136e-08 -1.95779592317e-12 1.3138e-08 -1.93406535582e-12 1.314e-08 -1.91062242816e-12 1.3142e-08 -1.8874636537e-12 1.3144e-08 -1.8645855882e-12 1.3146e-08 -1.84198482917e-12 1.3148e-08 -1.81965801536e-12 1.315e-08 -1.79760182626e-12 1.3152e-08 -1.77581298162e-12 1.3154e-08 -1.75428824093e-12 1.3156e-08 -1.73302440297e-12 1.3158e-08 -1.71201830533e-12 1.316e-08 -1.69126682392e-12 1.3162e-08 -1.67076687252e-12 1.3164e-08 -1.65051540231e-12 1.3166e-08 -1.63050940145e-12 1.3168e-08 -1.61074589458e-12 1.317e-08 -1.59122194242e-12 1.3172e-08 -1.57193464131e-12 1.3174e-08 -1.55288112279e-12 1.3176e-08 -1.53405855317e-12 1.3178e-08 -1.51546413309e-12 1.318e-08 -1.49709509714e-12 1.3182e-08 -1.47894871344e-12 1.3184e-08 -1.46102228319e-12 1.3186e-08 -1.44331314033e-12 1.3188e-08 -1.4258186511e-12 1.319e-08 -1.40853621367e-12 1.3192e-08 -1.39146325775e-12 1.3194e-08 -1.37459724421e-12 1.3196e-08 -1.35793566467e-12 1.3198e-08 -1.34147604119e-12 1.32e-08 -1.32521592583e-12 1.3202e-08 -1.30915290036e-12 1.3204e-08 -1.29328457582e-12 1.3206e-08 -1.27760859225e-12 1.3208e-08 -1.26212261825e-12 1.321e-08 -1.24682435072e-12 1.3212e-08 -1.23171151445e-12 1.3214e-08 -1.21678186182e-12 1.3216e-08 -1.20203317245e-12 1.3218e-08 -1.18746325287e-12 1.322e-08 -1.17306993619e-12 1.3222e-08 -1.15885108181e-12 1.3224e-08 -1.14480457506e-12 1.3226e-08 -1.1309283269e-12 1.3228e-08 -1.11722027362e-12 1.323e-08 -1.10367837651e-12 1.3232e-08 -1.09030062158e-12 1.3234e-08 -1.07708501927e-12 1.3236e-08 -1.0640296041e-12 1.3238e-08 -1.05113243443e-12 1.324e-08 -1.03839159217e-12 1.3242e-08 -1.02580518246e-12 1.3244e-08 -1.01337133341e-12 1.3246e-08 -1.00108819583e-12 1.3248e-08 -9.88953942931e-13 1.325e-08 -9.76966770072e-13 1.3252e-08 -9.65124894488e-13 1.3254e-08 -9.53426555022e-13 1.3256e-08 -9.41870011863e-13 1.3258e-08 -9.3045354629e-13 1.326e-08 -9.19175460413e-13 1.3262e-08 -9.08034076923e-13 1.3264e-08 -8.97027738843e-13 1.3266e-08 -8.86154809277e-13 1.3268e-08 -8.75413671174e-13 1.327e-08 -8.6480272708e-13 1.3272e-08 -8.54320398907e-13 1.3274e-08 -8.43965127691e-13 1.3276e-08 -8.33735373368e-13 1.3278e-08 -8.2362961454e-13 1.328e-08 -8.1364634825e-13 1.33e-08 0 ]
ic Xcell.Q=1.8 Xcell.QN=0 Xcell.S0=1.2 Xcell.S1=0
simOptions options temp=27 tnom=25 reltol=1e-5 vabstol=1e-6 iabstol=1e-12
tran tran stop=20n maxstep=10p errpreset=conservative
save WL WE PC BL BLB VDD:p Xcell.Q Xcell.QN Xcell.S0 Xcell.S1 VSEUMON:p
