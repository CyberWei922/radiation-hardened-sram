rhCellWindow=deOpenCellView("rh_sram_lib" "hphs12t" "schematic" "schematic" nil "r")
hiResizeWindow(rhCellWindow list(0:30 1610:1090))
hiZoomIn(rhCellWindow geGetWindowCellView(rhCellWindow)~>bBox)
hiRaiseWindow(rhCellWindow)
