simulator('spectre)
rhCellWindow=deOpenCellView("rh_sram_lib" "hphs12t" "schematic" "schematic" nil "r")
hiZoomIn(rhCellWindow geGetWindowCellView(rhCellWindow)~>bBox)
when(isDir("/home/rocky/work/rh_sram/runs/native/tb_hphs12t_seu/psf")
  load("scripts/review_waveforms.il")
  load("scripts/format_waveforms.il")
  hiRaiseWindow(rhCellWindow)
)
procedure(rhReviewCommands()
  let((path)
    path="/home/rocky/work/rh_sram/scripts/review_command.il"
    when(isFile(path)
      errset(load(path) t)
      deleteFile(path)
    )
    hiRegTimer("rhReviewCommands()" 20)
  )
)
rhReviewCommands()
