simulator lang=spectre
global 0
include "/home/rocky/work/iclab018um/models/spectre/rf018.scs" section=tt

// rh_sram_lib/sram6t/schematic
subckt sram6t BL BLB VDD VSS WL
    P2 (QN Q VDD VDD) pch l=0.18u w=0.3u m=1
    P1 (Q QN VDD VDD) pch l=0.18u w=0.3u m=1
    N4 (QN WL BLB VSS) nch l=0.18u w=0.4u m=1
    N3 (Q WL BL VSS) nch l=0.18u w=0.4u m=1
    N2 (QN Q VSS VSS) nch l=0.18u w=0.8u m=1
    N1 (Q QN VSS VSS) nch l=0.18u w=0.8u m=1
ends sram6t

// rh_sram_lib/tb_sram6t_functional/schematic
Xcell (BL BLB VDD VSS WL) sram6t
VSS_REF (VSS 0) vsource dc=0 type=dc
VSUPPLY (VDD 0) vsource dc=1.8 type=dc
VDATAB (DATAB 0) vsource type=pwl file="/home/rocky/work/rh_sram/stimuli/functional_DATAB.pwl"
VDATA (DATA 0) vsource type=pwl file="/home/rocky/work/rh_sram/stimuli/functional_DATA.pwl"
VPC (PC 0) vsource type=pwl file="/home/rocky/work/rh_sram/stimuli/functional_PC.pwl"
VWE (WE 0) vsource type=pwl file="/home/rocky/work/rh_sram/stimuli/functional_WE.pwl"
VWL (WL 0) vsource type=pwl file="/home/rocky/work/rh_sram/stimuli/functional_WL.pwl"
WBLB (BLB DATAB WE 0) relay vt1=.8 vt2=1 ropen=1T rclosed=1
WBL (BL DATA WE 0) relay vt1=.8 vt2=1 ropen=1T rclosed=1
PRE2 (BLB PC VDD VDD) pch l=0.18u w=2u m=1
PRE1 (BL PC VDD VDD) pch l=0.18u w=2u m=1
CBLB (BLB 0) capacitor c=100f
CBL (BL 0) capacitor c=100f

ic Xcell.Q=0 Xcell.QN=1.8
simOptions options temp=27 tnom=25 reltol=1e-5
tran tran stop=32n maxstep=10p errpreset=conservative
save WL WE PC BL BLB VSUPPLY:p Xcell.Q Xcell.QN
