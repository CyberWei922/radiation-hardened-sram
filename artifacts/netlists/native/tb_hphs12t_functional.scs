simulator lang=spectre
global 0
include "/home/rocky/work/iclab018um/models/spectre/rf018.scs" section=tt

// rh_sram_lib/hphs12t/schematic
subckt hphs12t BL BLB VDD VSS WL
    P2 (QN Q VDD VDD) pch l=0.18u w=0.3u m=1
    P1 (Q QN VDD VDD) pch l=0.18u w=0.3u m=1
    N10 (QN WL BLB VSS) nch l=0.18u w=0.4u m=1
    N9 (Q WL BL VSS) nch l=0.18u w=0.4u m=1
    N8 (S1 WL BLB VSS) nch l=0.18u w=0.4u m=1
    N7 (S0 WL BL VSS) nch l=0.18u w=0.4u m=1
    N6 (VDD QN S1 VSS) nch l=0.18u w=0.22u m=1
    N5 (VDD Q S0 VSS) nch l=0.18u w=0.22u m=1
    N4 (QN S0 S1 VSS) nch l=0.18u w=0.8u m=1
    N3 (Q S1 S0 VSS) nch l=0.18u w=0.8u m=1
    N2 (S1 S0 VSS VSS) nch l=0.18u w=2.4u m=1
    N1 (S0 S1 VSS VSS) nch l=0.18u w=2.4u m=1
ends hphs12t

// rh_sram_lib/tb_hphs12t_functional/schematic
Xcell (BL BLB VDD VSS WL) hphs12t
VSS_REF (VSS 0) vsource dc=0 type=dc
VSUPPLY (VDD 0) vsource dc=1.8 type=dc
VDATAB (DATAB 0) vsource type=pwl file="/home/rocky/work/rh_sram/stimuli/functional_DATAB.pwl"
VDATA (DATA 0) vsource type=pwl file="/home/rocky/work/rh_sram/stimuli/functional_DATA.pwl"
VPC (PC 0) vsource type=pwl file="/home/rocky/work/rh_sram/stimuli/functional_PC.pwl"
VWE (WE 0) vsource type=pwl file="/home/rocky/work/rh_sram/stimuli/functional_WE.pwl"
VWL (WL 0) vsource type=pwl file="/home/rocky/work/rh_sram/stimuli/functional_WL.pwl"
WBLB (BLB DATAB WE 0) relay vt1=.8 vt2=1 ropen=1T rclosed=1
WBL (BL DATA WE 0) relay vt1=.8 vt2=1 ropen=1T rclosed=1
PRE2 (BLB PC VDD VDD) pch l=0.18u w=2u m=1
PRE1 (BL PC VDD VDD) pch l=0.18u w=2u m=1
CBLB (BLB 0) capacitor c=100f
CBL (BL 0) capacitor c=100f

ic Xcell.Q=0 Xcell.QN=1.8 Xcell.S0=0 Xcell.S1=1.2
simOptions options temp=27 tnom=25 reltol=1e-5
tran tran stop=32n maxstep=10p errpreset=conservative
save WL WE PC BL BLB VSUPPLY:p Xcell.Q Xcell.QN Xcell.S0 Xcell.S1
